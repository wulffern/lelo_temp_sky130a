** generated by cicpy sch2subcells: LELOTEMP_BIAS_IBP as subcells
.subckt LELOTEMP_BIAS_IBP_BIP VD1 VD2 VSS
xe1 VD2 VD1 VSS JNWBIAS_BIPOLAR
.ends

.subckt LELOTEMP_BIAS_IBP_CAP_LPI_A LPI VDD_1V8
xd1<0> LPI VDD_1V8 REYATR_CAPX1
xd1<1> LPI VDD_1V8 REYATR_CAPX1
xd1<2> LPI VDD_1V8 REYATR_CAPX1
xd1<3> LPI VDD_1V8 REYATR_CAPX1
xd1<4> LPI VDD_1V8 REYATR_CAPX1
.ends

.subckt LELOTEMP_BIAS_IBP_CAP_LPI_B LPI VDD_1V8
xd1<5> LPI VDD_1V8 REYATR_CAPX1
xd1<6> LPI VDD_1V8 REYATR_CAPX1
xd1<7> LPI VDD_1V8 REYATR_CAPX1
xd1<8> LPI VDD_1V8 REYATR_CAPX1
xd1<9> LPI VDD_1V8 REYATR_CAPX1
.ends

.subckt LELOTEMP_BIAS_IBP_CAP_VCP VCP VDD_1V8
xd2<0> VCP VDD_1V8 REYATR_CAPX1
xd2<1> VCP VDD_1V8 REYATR_CAPX1
xd2<2> VCP VDD_1V8 REYATR_CAPX1
.ends

.subckt LELOTEMP_BIAS_IBP_N_G VD2 VR1 VSS
xg1 VR1 VR1 VD2 VSS REYATR_NCH_4C5F0
.ends

.subckt LELOTEMP_BIAS_IBP_OTA LPO PWRUP_1V8 PWRUP_N_1V8 VCP VD1 VDD_1V8 VR1 VSS
xad6 VDD_1V8 VR1 LPO VD1 VSS PWRUP_1V8 PWRUP_N_1V8 VCP LELOTEMP_OTAR
.ends

.subckt LELOTEMP_BIAS_IBP_P_CAS IBD<0> IBD<1> IBD<2> IBD<3> IBP_1U<0> IBP_1U<1> IBP_1U<2> IBP_1U<3> VBD1 VBD2 VCP VD1 VDD_1V8 VR1
xca2<0> IBP_1U<0> VCP IBD<0> VDD_1V8 REYATR_PCH_4C1F2
xca2<1> IBP_1U<1> VCP IBD<1> VDD_1V8 REYATR_PCH_4C1F2
xca2<2> IBP_1U<2> VCP IBD<2> VDD_1V8 REYATR_PCH_4C1F2
xca2<3> IBP_1U<3> VCP IBD<3> VDD_1V8 REYATR_PCH_4C1F2
xca4 VR1 VCP VBD2 VDD_1V8 REYATR_PCH_4C1F2
xca5<0> VD1 VCP VBD1 VDD_1V8 REYATR_PCH_4C1F2
xca5<1> VD1 VCP VBD1 VDD_1V8 REYATR_PCH_4C1F2
xca5<2> VD1 VCP VBD1 VDD_1V8 REYATR_PCH_4C1F2
xca5<3> VD1 VCP VBD1 VDD_1V8 REYATR_PCH_4C1F2
xca5<4> VD1 VCP VBD1 VDD_1V8 REYATR_PCH_4C1F2
xca5<5> VD1 VCP VBD1 VDD_1V8 REYATR_PCH_4C1F2
xca5<6> VD1 VCP VBD1 VDD_1V8 REYATR_PCH_4C1F2
xca5<7> VD1 VCP VBD1 VDD_1V8 REYATR_PCH_4C1F2
.ends

.subckt LELOTEMP_BIAS_IBP_P_CC VDD_1V8
xcc<0> VDD_1V8 VDD_1V8 VDD_1V8 VDD_1V8 REYATR_PCH_4C5F0
xcc<1> VDD_1V8 VDD_1V8 VDD_1V8 VDD_1V8 REYATR_PCH_4C5F0
xcc<2> VDD_1V8 VDD_1V8 VDD_1V8 VDD_1V8 REYATR_PCH_4C5F0
xcc<3> VDD_1V8 VDD_1V8 VDD_1V8 VDD_1V8 REYATR_PCH_4C5F0
xcc<4> VDD_1V8 VDD_1V8 VDD_1V8 VDD_1V8 REYATR_PCH_4C5F0
xfill_p_cc_0 VDD_1V8 VDD_1V8 VDD_1V8 VDD_1V8 REYATR_PCH_4C5F0
xfill_p_cc_1 VDD_1V8 VDD_1V8 VDD_1V8 VDD_1V8 REYATR_PCH_4C5F0
xfill_p_cc_2 VDD_1V8 VDD_1V8 VDD_1V8 VDD_1V8 REYATR_PCH_4C5F0
xfill_p_cc_3 VDD_1V8 VDD_1V8 VDD_1V8 VDD_1V8 REYATR_PCH_4C5F0
xfill_p_cc_4 VDD_1V8 VDD_1V8 VDD_1V8 VDD_1V8 REYATR_PCH_4C5F0
xfill_p_cc_5 VDD_1V8 VDD_1V8 VDD_1V8 VDD_1V8 REYATR_PCH_4C5F0
xfill_p_cc_6 VDD_1V8 VDD_1V8 VDD_1V8 VDD_1V8 REYATR_PCH_4C5F0
xfill_p_cc_7 VDD_1V8 VDD_1V8 VDD_1V8 VDD_1V8 REYATR_PCH_4C5F0
.ends

.subckt LELOTEMP_BIAS_IBP_P_SRC IBD<0> IBD<1> IBD<2> IBD<3> LPI VBD1 VBD2 VDD_1V8
xca1<0> VBD1 LPI VDD_1V8 VDD_1V8 REYATR_PCH_4C5F0
xca1<1> VBD1 LPI VDD_1V8 VDD_1V8 REYATR_PCH_4C5F0
xca1<2> VBD1 LPI VDD_1V8 VDD_1V8 REYATR_PCH_4C5F0
xca1<3> VBD1 LPI VDD_1V8 VDD_1V8 REYATR_PCH_4C5F0
xca1<4> VBD1 LPI VDD_1V8 VDD_1V8 REYATR_PCH_4C5F0
xca1<5> VBD1 LPI VDD_1V8 VDD_1V8 REYATR_PCH_4C5F0
xca1<6> VBD1 LPI VDD_1V8 VDD_1V8 REYATR_PCH_4C5F0
xca1<7> VBD1 LPI VDD_1V8 VDD_1V8 REYATR_PCH_4C5F0
xca2 VBD2 LPI VDD_1V8 VDD_1V8 REYATR_PCH_4C5F0
xca3<0> IBD<0> LPI VDD_1V8 VDD_1V8 REYATR_PCH_4C5F0
xca3<1> IBD<1> LPI VDD_1V8 VDD_1V8 REYATR_PCH_4C5F0
xca3<2> IBD<2> LPI VDD_1V8 VDD_1V8 REYATR_PCH_4C5F0
xca3<3> IBD<3> LPI VDD_1V8 VDD_1V8 REYATR_PCH_4C5F0
.ends

.subckt LELOTEMP_BIAS_IBP_P_SU VD1 VDD_1V8
xfill_p_su_0 VDD_1V8 VDD_1V8 VDD_1V8 VDD_1V8 REYATR_PCH_2C5F0
xfill_p_su_1 VDD_1V8 VDD_1V8 VDD_1V8 VDD_1V8 REYATR_PCH_2C5F0
xfill_p_su_10 VDD_1V8 VDD_1V8 VDD_1V8 VDD_1V8 REYATR_PCH_2C5F0
xfill_p_su_2 VDD_1V8 VDD_1V8 VDD_1V8 VDD_1V8 REYATR_PCH_2C5F0
xfill_p_su_3 VDD_1V8 VDD_1V8 VDD_1V8 VDD_1V8 REYATR_PCH_2C5F0
xfill_p_su_4 VDD_1V8 VDD_1V8 VDD_1V8 VDD_1V8 REYATR_PCH_2C5F0
xfill_p_su_5 VDD_1V8 VDD_1V8 VDD_1V8 VDD_1V8 REYATR_PCH_2C5F0
xfill_p_su_6 VDD_1V8 VDD_1V8 VDD_1V8 VDD_1V8 REYATR_PCH_2C5F0
xfill_p_su_7 VDD_1V8 VDD_1V8 VDD_1V8 VDD_1V8 REYATR_PCH_2C5F0
xfill_p_su_8 VDD_1V8 VDD_1V8 VDD_1V8 VDD_1V8 REYATR_PCH_2C5F0
xfill_p_su_9 VDD_1V8 VDD_1V8 VDD_1V8 VDD_1V8 REYATR_PCH_2C5F0
xsu1 VSU VSU VDD_1V8 VDD_1V8 REYATR_PCH_2C5F0
xsu2 VD1 VD1 VSU VDD_1V8 REYATR_PCH_2C5F0
.ends

.subckt LELOTEMP_BIAS_IBP_R_LAD VD2 VR1 VSS
xd3<0> R1<0> VD2 VSS REYATR_RES_36C2F0
xd3<1> R1<1> R1<0> VSS REYATR_RES_36C2F0
xd3<2> R1<2> R1<1> VSS REYATR_RES_36C2F0
xd3<3> R1<3> R1<2> VSS REYATR_RES_36C2F0
xd3<4> R1<4> R1<3> VSS REYATR_RES_36C2F0
xd3<5> VR1 R1<4> VSS REYATR_RES_36C2F0
.ends

.subckt LELOTEMP_BIAS_IBP_HIER VDD_1V8 LPI IBP_1U<3> IBP_1U<2> IBP_1U<1> IBP_1U<0> LPO VD1 PWRUP_1V8 VSS PWRUP_N_1V8
xbip VD1 VD2 VSS LELOTEMP_BIAS_IBP_BIP
xcap_lpi_a LPI VDD_1V8 LELOTEMP_BIAS_IBP_CAP_LPI_A
xcap_lpi_b LPI VDD_1V8 LELOTEMP_BIAS_IBP_CAP_LPI_B
xcap_vcp VCP VDD_1V8 LELOTEMP_BIAS_IBP_CAP_VCP
xn_g VD2 VR1 VSS LELOTEMP_BIAS_IBP_N_G
xota LPO PWRUP_1V8 PWRUP_N_1V8 VCP VD1 VDD_1V8 VR1 VSS LELOTEMP_BIAS_IBP_OTA
xp_cas IBD<0> IBD<1> IBD<2> IBD<3> IBP_1U<0> IBP_1U<1> IBP_1U<2> IBP_1U<3> VBD1 VBD2 VCP VD1 VDD_1V8 VR1 LELOTEMP_BIAS_IBP_P_CAS
xp_cc VDD_1V8 LELOTEMP_BIAS_IBP_P_CC
xp_src IBD<0> IBD<1> IBD<2> IBD<3> LPI VBD1 VBD2 VDD_1V8 LELOTEMP_BIAS_IBP_P_SRC
xp_su VD1 VDD_1V8 LELOTEMP_BIAS_IBP_P_SU
xr_lad VD2 VR1 VSS LELOTEMP_BIAS_IBP_R_LAD
.ends
