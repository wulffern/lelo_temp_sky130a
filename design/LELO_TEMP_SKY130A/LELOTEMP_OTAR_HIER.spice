** generated by cicpy sch2subcells: LELOTEMP_OTAR as subcells
.subckt LELOTEMP_OTAR_N_LOAD_A PWRUP_N_1V8 VBP VD1 VSS
xnd1<0> VD1 VD1 VSS VSS REYATR_NCH_4C5F0
xnd1<1> VD1 VD1 VSS VSS REYATR_NCH_4C5F0
xnd1<2> VD1 VD1 VSS VSS REYATR_NCH_4C5F0
xnd3 VBP VD1 VSS VSS REYATR_NCH_4C5F0
xns1 VD1 PWRUP_N_1V8 VSS VSS REYATR_NCH_4C5F0
.ends

.subckt LELOTEMP_OTAR_N_LOAD_B PWRUP_N_1V8 VD2 VO VSS
xnd2<0> VD2 VD2 VSS VSS REYATR_NCH_4C5F0
xnd2<1> VD2 VD2 VSS VSS REYATR_NCH_4C5F0
xnd2<2> VD2 VD2 VSS VSS REYATR_NCH_4C5F0
xnd4 VO VD2 VSS VSS REYATR_NCH_4C5F0
xns2 VD2 PWRUP_N_1V8 VSS VSS REYATR_NCH_4C5F0
.ends

.subckt LELOTEMP_OTAR_N_MIRR PWRUP_N_1V8 VCP VD3 VSS
xnc0 VD3 VD3 VSS VSS REYATR_NCH_4C5F0
xnc1<0> VCP VD3 VSS VSS REYATR_NCH_4C5F0
xnc1<1> VCP VD3 VSS VSS REYATR_NCH_4C5F0
xnc1<2> VCP VD3 VSS VSS REYATR_NCH_4C5F0
xns4 VD3 PWRUP_N_1V8 VSS VSS REYATR_NCH_4C5F0
.ends

.subckt LELOTEMP_OTAR_P_BIAS PWRUP_1V8 PWRUP_N_1V8 VBP VCP VDD_1V8 VDS VO
xba1 VDS PWRUP_N_1V8 VDD_1V8 VDD_1V8 REYATR_PCH_11C5F0
xba2 VO PWRUP_1V8 VDD_1V8 VDD_1V8 REYATR_PCH_11C5F0
xba3 VCP PWRUP_1V8 VDD_1V8 VDD_1V8 REYATR_PCH_11C5F0
xba6 VBP VBP VDD_1V8 VDD_1V8 REYATR_PCH_11C5F0
xba7 VBP PWRUP_1V8 VDD_1V8 VDD_1V8 REYATR_PCH_11C5F0
xba8 VO VBP VDD_1V8 VDD_1V8 REYATR_PCH_11C5F0
xfill_p_bias_0 xfill_p_bias_0_f0 xfill_p_bias_0_f1 VDD_1V8 xfill_p_bias_0_f3 REYATR_PCH_11C5F0
.ends

.subckt LELOTEMP_OTAR_P_IN_A VD1 VD3 VDD_1V8 VIN VS
xbl1<0> VD1 VIN VS VDD_1V8 REYATR_LVT_PCH_11C5F0
xbl1<1> VD1 VIN VS VDD_1V8 REYATR_LVT_PCH_11C5F0
xbl1<2> VD1 VIN VS VDD_1V8 REYATR_LVT_PCH_11C5F0
xbl1<3> VD1 VIN VS VDD_1V8 REYATR_LVT_PCH_11C5F0
xbl1<4> VD1 VIN VS VDD_1V8 REYATR_LVT_PCH_11C5F0
xbl1<5> VD1 VIN VS VDD_1V8 REYATR_LVT_PCH_11C5F0
xbl4 VD3 VIN VS VDD_1V8 REYATR_LVT_PCH_11C5F0
.ends

.subckt LELOTEMP_OTAR_P_IN_B VD2 VD3 VDD_1V8 VIP VS
xbl2<0> VD2 VIP VS VDD_1V8 REYATR_LVT_PCH_11C5F0
xbl2<1> VD2 VIP VS VDD_1V8 REYATR_LVT_PCH_11C5F0
xbl2<2> VD2 VIP VS VDD_1V8 REYATR_LVT_PCH_11C5F0
xbl2<3> VD2 VIP VS VDD_1V8 REYATR_LVT_PCH_11C5F0
xbl2<4> VD2 VIP VS VDD_1V8 REYATR_LVT_PCH_11C5F0
xbl2<5> VD2 VIP VS VDD_1V8 REYATR_LVT_PCH_11C5F0
xbl5 VD3 VIP VS VDD_1V8 REYATR_LVT_PCH_11C5F0
.ends

.subckt LELOTEMP_OTAR_P_SW VCP VDD_1V8
xbs1 net2 VCP net1 VDD_1V8 REYATR_PCH_4C1F2
xbs2 net4 VCP net2 VDD_1V8 REYATR_PCH_4C1F2
xbs4 net3 VCP net4 VDD_1V8 REYATR_PCH_4C1F2
xbs6 net1 VCP VDD_1V8 VDD_1V8 REYATR_PCH_4C1F2
xbs7 net5 VCP net3 VDD_1V8 REYATR_PCH_4C1F2
xbs8 VCP VCP net5 VDD_1V8 REYATR_PCH_4C1F2
xfill_p_sw_0 xfill_p_sw_0_f0 xfill_p_sw_0_f1 xfill_p_sw_0_f2 VDD_1V8 REYATR_PCH_4C1F2
.ends

.subckt LELOTEMP_OTAR_R_DEG VDS VS VSS
xd2<0> R1<0> VS VSS REYATR_RES_36C2F0
xd2<1> VDS R1<0> VSS REYATR_RES_36C2F0
.ends

.subckt LELOTEMP_OTAR_HIER VDD_1V8 VIP VO VIN VSS PWRUP_1V8 PWRUP_N_1V8 VCP
xn_load_a PWRUP_N_1V8 VBP VD1 VSS LELOTEMP_OTAR_N_LOAD_A
xn_load_b PWRUP_N_1V8 VD2 VO VSS LELOTEMP_OTAR_N_LOAD_B
xn_mirr PWRUP_N_1V8 VCP VD3 VSS LELOTEMP_OTAR_N_MIRR
xp_bias PWRUP_1V8 PWRUP_N_1V8 VBP VCP VDD_1V8 VDS VO LELOTEMP_OTAR_P_BIAS
xp_in_a VD1 VD3 VDD_1V8 VIN VS LELOTEMP_OTAR_P_IN_A
xp_in_b VD2 VD3 VDD_1V8 VIP VS LELOTEMP_OTAR_P_IN_B
xp_sw VCP VDD_1V8 LELOTEMP_OTAR_P_SW
xr_deg VDS VS VSS LELOTEMP_OTAR_R_DEG
.ends
