* generated by cicpy write_stack_cells
* fingerprint 6a1f40e1054c
* DO NOT EDIT -- regenerated every run from
* the parent netlist and the stack grouping
.subckt LELOTEMP_OTAR_N_LOAD_A PWRUP_N_1V8 VBP VD1 VSS
xnd1<0> VD1 VD1 VSS VSS REYATR_NCH_4C5F0D
xnd1<1> VD1 VD1 VSS VSS REYATR_NCH_4C5F0D
xnd1<2> VD1 VD1 VSS VSS REYATR_NCH_4C5F0D
xnd3 VBP VD1 VSS VSS REYATR_NCH_4C5F0
xns1 VD1 PWRUP_N_1V8 VSS VSS REYATR_NCH_4C5F0
xstack_n_load_a_bot  REYATR_NCH_4CTAPBOT
xstack_n_load_a_top  REYATR_NCH_4CTAPTOP
.ends
