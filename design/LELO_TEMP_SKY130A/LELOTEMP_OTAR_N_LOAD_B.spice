* generated by cicpy write_stack_cells
* fingerprint 1aea18b4dbe6
* DO NOT EDIT -- regenerated every run from
* the parent netlist and the stack grouping
.subckt LELOTEMP_OTAR_N_LOAD_B PWRUP_N_1V8 VD2 VO VSS
xnd2<0> VD2 VD2 VSS VSS REYATR_NCH_4C5F0D
xnd2<1> VD2 VD2 VSS VSS REYATR_NCH_4C5F0D
xnd2<2> VD2 VD2 VSS VSS REYATR_NCH_4C5F0D
xnd4 VO VD2 VSS VSS REYATR_NCH_4C5F0
xns2 VD2 PWRUP_N_1V8 VSS VSS REYATR_NCH_4C5F0
xstack_n_load_b_bot  REYATR_NCH_4CTAPBOT
xstack_n_load_b_top  REYATR_NCH_4CTAPTOP
.ends
