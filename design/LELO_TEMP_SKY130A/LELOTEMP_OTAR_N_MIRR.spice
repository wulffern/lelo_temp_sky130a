* generated by cicpy write_stack_cells
* fingerprint 3459bb1ed455
* DO NOT EDIT -- regenerated every run from
* the parent netlist and the stack grouping
.subckt LELOTEMP_OTAR_N_MIRR PWRUP_N_1V8 VCP VD3 VSS
xnc0 VD3 VD3 VSS VSS REYATR_NCH_4C5F0D
xnc1<0> VCP VD3 VSS VSS REYATR_NCH_4C5F0
xnc1<1> VCP VD3 VSS VSS REYATR_NCH_4C5F0
xnc1<2> VCP VD3 VSS VSS REYATR_NCH_4C5F0
xns4 VD3 PWRUP_N_1V8 VSS VSS REYATR_NCH_4C5F0
xstack_n_mirr_bot  REYATR_NCH_4CTAPBOT
xstack_n_mirr_top  REYATR_NCH_4CTAPTOP
.ends
