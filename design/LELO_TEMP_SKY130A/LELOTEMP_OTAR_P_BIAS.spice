* generated by cicpy write_stack_cells
* fingerprint 28b1819c5817
* DO NOT EDIT -- regenerated every run from
* the parent netlist and the stack grouping
.subckt LELOTEMP_OTAR_P_BIAS PWRUP_N_1V8 VBP VCP VDD_1V8 VDS VO
xba1 VDS PWRUP_N_1V8 VDD_1V8 VDD_1V8 REYATR_PCH_11C5F0
xba2 VO PWRUP_1V8 VDD_1V8 VDD_1V8 REYATR_PCH_11C5F0
xba3 VCP PWRUP_1V8 VDD_1V8 VDD_1V8 REYATR_PCH_11C5F0
xba6 VBP VBP VDD_1V8 VDD_1V8 REYATR_PCH_11C5F0D
xba7 VBP PWRUP_1V8 VDD_1V8 VDD_1V8 REYATR_PCH_11C5F0
xba8 VO VBP VDD_1V8 VDD_1V8 REYATR_PCH_11C5F0
xfill_p_bias_0  REYATR_PCH_11C5F0
xstack_p_bias_bot  REYATR_PCH_11CTAPBOT
xstack_p_bias_top  REYATR_PCH_11CTAPTOP
.ends
