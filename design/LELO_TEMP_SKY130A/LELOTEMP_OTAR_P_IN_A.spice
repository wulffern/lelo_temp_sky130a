* generated by cicpy write_stack_cells
* fingerprint 400ea88848b7
* DO NOT EDIT -- regenerated every run from
* the parent netlist and the stack grouping
.subckt LELOTEMP_OTAR_P_IN_A VD1 VD3 VDD_1V8 VS
xbl1<0> VD1 VIN VS VDD_1V8 REYATR_LVT_PCH_11C5F0
xbl1<1> VD1 VIN VS VDD_1V8 REYATR_LVT_PCH_11C5F0
xbl1<2> VD1 VIN VS VDD_1V8 REYATR_LVT_PCH_11C5F0
xbl1<3> VD1 VIN VS VDD_1V8 REYATR_LVT_PCH_11C5F0
xbl1<4> VD1 VIN VS VDD_1V8 REYATR_LVT_PCH_11C5F0
xbl1<5> VD1 VIN VS VDD_1V8 REYATR_LVT_PCH_11C5F0
xbl4 VD3 VIN VS VDD_1V8 REYATR_LVT_PCH_11C5F0
xstack_p_in_a_bot  REYATR_PCH_11CTAPBOT
xstack_p_in_a_top  REYATR_PCH_11CTAPTOP
.ends
