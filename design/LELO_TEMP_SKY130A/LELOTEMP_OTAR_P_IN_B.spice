* generated by cicpy write_stack_cells
* fingerprint c60a9dcff7e4
* DO NOT EDIT -- regenerated every run from
* the parent netlist and the stack grouping
.subckt LELOTEMP_OTAR_P_IN_B VD2 VD3 VDD_1V8 VS
xbl2<0> VD2 VIP VS VDD_1V8 REYATR_LVT_PCH_11C5F0
xbl2<1> VD2 VIP VS VDD_1V8 REYATR_LVT_PCH_11C5F0
xbl2<2> VD2 VIP VS VDD_1V8 REYATR_LVT_PCH_11C5F0
xbl2<3> VD2 VIP VS VDD_1V8 REYATR_LVT_PCH_11C5F0
xbl2<4> VD2 VIP VS VDD_1V8 REYATR_LVT_PCH_11C5F0
xbl2<5> VD2 VIP VS VDD_1V8 REYATR_LVT_PCH_11C5F0
xbl5 VD3 VIP VS VDD_1V8 REYATR_LVT_PCH_11C5F0
xstack_p_in_b_bot  REYATR_PCH_11CTAPBOT
xstack_p_in_b_top  REYATR_PCH_11CTAPTOP
.ends
