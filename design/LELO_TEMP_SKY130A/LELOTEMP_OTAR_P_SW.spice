* generated by cicpy write_stack_cells
* fingerprint 8c40b30c2fc6
* DO NOT EDIT -- regenerated every run from
* the parent netlist and the stack grouping
.subckt LELOTEMP_OTAR_P_SW VCP VDD_1V8
xbs1 net2 VCP net1 VDD_1V8 REYATR_PCH_4C1F2
xbs2 net4 VCP net2 VDD_1V8 REYATR_PCH_4C1F2
xbs4 net3 VCP net4 VDD_1V8 REYATR_PCH_4C1F2
xbs6 net1 VCP VDD_1V8 VDD_1V8 REYATR_PCH_4C1F2
xbs7 net5 VCP net3 VDD_1V8 REYATR_PCH_4C1F2
xbs8 VCP VCP net5 VDD_1V8 REYATR_PCH_4C1F2D
xfill_p_sw_0  REYATR_PCH_4C1F2D
xstack_p_sw_bot  REYATR_PCH_4CTAPBOT
xstack_p_sw_top  REYATR_PCH_4CTAPTOP
.ends
