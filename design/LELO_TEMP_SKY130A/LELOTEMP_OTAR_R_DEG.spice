* generated by cicpy write_stack_cells
* fingerprint 176688104632
* DO NOT EDIT -- regenerated every run from
* the parent netlist and the stack grouping
.subckt LELOTEMP_OTAR_R_DEG VDS VS VSS
xd2<0> R1<0> VS VSS REYATR_RES_36C2F0
xd2<1> VDS R1<0> VSS REYATR_RES_36C2F0
xstack_r_deg_bot  REYATR_RES_36CTAPBOT
xstack_r_deg_top  REYATR_RES_36CTAPTOP
.ends
