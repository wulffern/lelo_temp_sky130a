** sch_path: /Users/wulff/data/2023/aicex/ip/lelo_temp_sky130a/design/LELO_TEMP_SKY130A/LELOTEMP_BIAS_IBP.sch
**.subckt LELOTEMP_BIAS_IBP VDD_1V8 LPI IBP_1U<3>,IBP_1U<2>,IBP_1U<1>,IBP_1U<0> LPO VD1 PWRUP_1V8 VSS PWRUP_N_1V8
*.ipin VDD_1V8
*.ipin VSS
*.ipin LPI
*.opin LPO
*.opin IBP_1U<3>,IBP_1U<2>,IBP_1U<1>,IBP_1U<0>
*.opin VD1
*.ipin PWRUP_1V8
*.ipin PWRUP_N_1V8
xca2 VBD2 LPI VDD_1V8 VDD_1V8 JNWATR_PCH_4C5F0
xca1<7> VBD1 LPI VDD_1V8 VDD_1V8 JNWATR_PCH_4C5F0
xca1<6> VBD1 LPI VDD_1V8 VDD_1V8 JNWATR_PCH_4C5F0
xca1<5> VBD1 LPI VDD_1V8 VDD_1V8 JNWATR_PCH_4C5F0
xca1<4> VBD1 LPI VDD_1V8 VDD_1V8 JNWATR_PCH_4C5F0
xca1<3> VBD1 LPI VDD_1V8 VDD_1V8 JNWATR_PCH_4C5F0
xca1<2> VBD1 LPI VDD_1V8 VDD_1V8 JNWATR_PCH_4C5F0
xca1<1> VBD1 LPI VDD_1V8 VDD_1V8 JNWATR_PCH_4C5F0
xca1<0> VBD1 LPI VDD_1V8 VDD_1V8 JNWATR_PCH_4C5F0
xd1<4> LPI VDD_1V8 JNWTR_CAPX1
xd1<3> LPI VDD_1V8 JNWTR_CAPX1
xd1<2> LPI VDD_1V8 JNWTR_CAPX1
xd1<1> LPI VDD_1V8 JNWTR_CAPX1
xd1<0> LPI VDD_1V8 JNWTR_CAPX1
xad6 VDD_1V8 VR1 LPO VD1 VSS PWRUP_1V8 PWRUP_N_1V8 VCP LELOTEMP_OTAN
xca3<3> IBD<3> LPI VDD_1V8 VDD_1V8 JNWATR_PCH_4C5F0
xca3<2> IBD<2> LPI VDD_1V8 VDD_1V8 JNWATR_PCH_4C5F0
xca3<1> IBD<1> LPI VDD_1V8 VDD_1V8 JNWATR_PCH_4C5F0
xca3<0> IBD<0> LPI VDD_1V8 VDD_1V8 JNWATR_PCH_4C5F0
xac2 VD2 net1 VSS JNWTR_RPPO4
xe1 VD2 VD1 VSS JNWBIAS_BIPOLAR
xg1 VR1 VR1 VD2 VSS JNWATR_NCH_4C5F0
xac3 net1 VR1 VSS JNWTR_RPPO8
xcc<4> VDD_1V8 VDD_1V8 VDD_1V8 VDD_1V8 JNWATR_PCH_4C5F0
xcc<3> VDD_1V8 VDD_1V8 VDD_1V8 VDD_1V8 JNWATR_PCH_4C5F0
xcc<2> VDD_1V8 VDD_1V8 VDD_1V8 VDD_1V8 JNWATR_PCH_4C5F0
xcc<1> VDD_1V8 VDD_1V8 VDD_1V8 VDD_1V8 JNWATR_PCH_4C5F0
xcc<0> VDD_1V8 VDD_1V8 VDD_1V8 VDD_1V8 JNWATR_PCH_4C5F0
xca2<3> IBP_1U<3> VCP IBD<3> VDD_1V8 JNWATR_PCH_4C1F2
xca2<2> IBP_1U<2> VCP IBD<2> VDD_1V8 JNWATR_PCH_4C1F2
xca2<1> IBP_1U<1> VCP IBD<1> VDD_1V8 JNWATR_PCH_4C1F2
xca2<0> IBP_1U<0> VCP IBD<0> VDD_1V8 JNWATR_PCH_4C1F2
xca4 VR1 VCP VBD2 VDD_1V8 JNWATR_PCH_4C1F2
xca5<7> VD1 VCP VBD1 VDD_1V8 JNWATR_PCH_4C1F2
xca5<6> VD1 VCP VBD1 VDD_1V8 JNWATR_PCH_4C1F2
xca5<5> VD1 VCP VBD1 VDD_1V8 JNWATR_PCH_4C1F2
xca5<4> VD1 VCP VBD1 VDD_1V8 JNWATR_PCH_4C1F2
xca5<3> VD1 VCP VBD1 VDD_1V8 JNWATR_PCH_4C1F2
xca5<2> VD1 VCP VBD1 VDD_1V8 JNWATR_PCH_4C1F2
xca5<1> VD1 VCP VBD1 VDD_1V8 JNWATR_PCH_4C1F2
xca5<0> VD1 VCP VBD1 VDD_1V8 JNWATR_PCH_4C1F2
xca1 VSS VR1 net2 VDD_1V8 JNWATR_PCH_4C1F2
xg2 LPI PWRUP_1V8 net2 VSS JNWATR_NCH_4C5F0
xg4 VCP PWRUP_1V8 net3 VSS JNWATR_NCH_4C5F0
xca3 VSS VR1 net3 VDD_1V8 JNWATR_PCH_4C1F2
**.ends

* expanding   symbol:  JNW_ATR_SKY130A/JNWATR_PCH_4C5F0.sym # of pins=4
** sym_path: /Users/wulff/data/2023/aicex/ip/lelo_temp_sky130a/design/JNW_ATR_SKY130A/JNWATR_PCH_4C5F0.sym
** sch_path: /Users/wulff/data/2023/aicex/ip/lelo_temp_sky130a/design/JNW_ATR_SKY130A/JNWATR_PCH_4C5F0.sch
.subckt JNWATR_PCH_4C5F0 D G S B
*.iopin D
*.iopin G
*.iopin S
*.iopin B
XM1 D G S B sky130_fd_pr__pfet_01v8 L=0.94 W=3.2 nf=2 ad='int((nf+1)/2) * W/nf * 0.29' as='int((nf+2)/2) * W/nf * 0.29' pd='2*int((nf+1)/2) * (W/nf + 0.29)'
+ ps='2*int((nf+2)/2) * (W/nf + 0.29)' nrd='0.29 / W' nrs='0.29 / W' sa=0 sb=0 sd=0 mult=1 m=1
.ends

* expanding   symbol:  JNW_TR_SKY130A/JNWTR_CAPX1.sym # of pins=2
** sym_path: /Users/wulff/data/2023/aicex/ip/lelo_temp_sky130a/design/JNW_TR_SKY130A/JNWTR_CAPX1.sym
** sch_path: /Users/wulff/data/2023/aicex/ip/lelo_temp_sky130a/design/JNW_TR_SKY130A/JNWTR_CAPX1.sch
.subckt JNWTR_CAPX1 A B
*.iopin A
*.iopin B
XC1 B A sky130_fd_pr__cap_mim_m3_1 W=5 L=5 MF=1 m=1
.ends

* expanding   symbol:  LELO_TEMP_SKY130A/LELOTEMP_OTAN.sym # of pins=8
** sym_path: /Users/wulff/data/2023/aicex/ip/lelo_temp_sky130a/design/LELO_TEMP_SKY130A/LELOTEMP_OTAN.sym
** sch_path: /Users/wulff/data/2023/aicex/ip/lelo_temp_sky130a/design/LELO_TEMP_SKY130A/LELOTEMP_OTAN.sch
.subckt LELOTEMP_OTAN VDD_1V8 VIP VO VIN VSS PWRUP_1V8 PWRUP_N_1V8 VCP
*.ipin VDD_1V8
*.ipin VSS
*.ipin PWRUP_N_1V8
*.ipin PWRUP_1V8
*.opin VO
*.ipin VIP
*.ipin VIN
*.opin VCP
xca3 VDN1 VBN VSS VSS JNWATR_NCH_4C5F0
xbb1<3> VBP2 VIN VS VSS LELOATR_LVT_NCH_4C5F0
xbb1<2> VBP2 VIN VS VSS LELOATR_LVT_NCH_4C5F0
xbb1<1> VBP2 VIN VS VSS LELOATR_LVT_NCH_4C5F0
xbb1<0> VBP2 VIN VS VSS LELOATR_LVT_NCH_4C5F0
xbb2<3> VBP1 VIP VS VSS LELOATR_LVT_NCH_4C5F0
xbb2<2> VBP1 VIP VS VSS LELOATR_LVT_NCH_4C5F0
xbb2<1> VBP1 VIP VS VSS LELOATR_LVT_NCH_4C5F0
xbb2<0> VBP1 VIP VS VSS LELOATR_LVT_NCH_4C5F0
xd2 net1 net7 VSS JNWTR_RPPO4
xca1 net1 PWRUP_1V8 VSS VSS JNWATR_NCH_4C5F0
x3 VCP VIN VS2 VSS LELOATR_LVT_NCH_4C5F0
x4 VCP VIP VS2 VSS LELOATR_LVT_NCH_4C5F0
xba1<1> net4<1> VBP2 VDD_1V8 VDD_1V8 JNWATR_PCH_4C5F0
xba1<0> net4<0> VBP2 VDD_1V8 VDD_1V8 JNWATR_PCH_4C5F0
xba2<1> net2<1> VBP1 VDD_1V8 VDD_1V8 JNWATR_PCH_4C5F0
xba2<0> net2<0> VBP1 VDD_1V8 VDD_1V8 JNWATR_PCH_4C5F0
xba3<1> VBP2 VCP net4<1> VDD_1V8 JNWATR_PCH_4C1F2
xba3<0> VBP2 VCP net4<0> VDD_1V8 JNWATR_PCH_4C1F2
xba4<1> VBP1 VCP net2<1> VDD_1V8 JNWATR_PCH_4C1F2
xba4<0> VBP1 VCP net2<0> VDD_1V8 JNWATR_PCH_4C1F2
xba5 net3 VBP1 VDD_1V8 VDD_1V8 JNWATR_PCH_4C5F0
xba7 VO VCP net3 VDD_1V8 JNWATR_PCH_4C1F2
xba8 VDP1 VBP2 VDD_1V8 VDD_1V8 JNWATR_PCH_4C5F0
xba9 VBN VCP VDP1 VDD_1V8 JNWATR_PCH_4C1F2
xca2 VBN VCN VDN1 VSS JNWATR_NCH_4C1F2
xca4 net5 VBN VSS VSS JNWATR_NCH_4C5F0
xca5 VO VCN net5 VSS JNWATR_NCH_4C1F2
xba6 VBP2 PWRUP_1V8 VDD_1V8 VDD_1V8 JNWATR_PCH_12C5F0
xba11 VBP1 PWRUP_1V8 VDD_1V8 VDD_1V8 JNWATR_PCH_12C5F0
xca6 VBN PWRUP_N_1V8 VSS VSS JNWATR_NCH_4C5F0
xbb3<5> VC_SER<4> VCP VDD_1V8 VDD_1V8 JNWATR_PCH_4C1F2
xbb3<4> VC_SER<3> VCP VC_SER<4> VDD_1V8 JNWATR_PCH_4C1F2
xbb3<3> VC_SER<2> VCP VC_SER<3> VDD_1V8 JNWATR_PCH_4C1F2
xbb3<2> VC_SER<1> VCP VC_SER<2> VDD_1V8 JNWATR_PCH_4C1F2
xbb3<1> VC_SER<0> VCP VC_SER<1> VDD_1V8 JNWATR_PCH_4C1F2
xbb3<0> VCP VCP VC_SER<0> VDD_1V8 JNWATR_PCH_4C1F2
xbb4<5> VC_SER<4> VCP VDD_1V8 VDD_1V8 JNWATR_PCH_4C1F2
xbb4<4> VC_SER<3> VCP VC_SER<4> VDD_1V8 JNWATR_PCH_4C1F2
xbb4<3> VC_SER<2> VCP VC_SER<3> VDD_1V8 JNWATR_PCH_4C1F2
xbb4<2> VC_SER<1> VCP VC_SER<2> VDD_1V8 JNWATR_PCH_4C1F2
xbb4<1> VC_SER<0> VCP VC_SER<1> VDD_1V8 JNWATR_PCH_4C1F2
xbb4<0> VCN VCP VC_SER<0> VDD_1V8 JNWATR_PCH_4C1F2
xca7<5> VCN VCN VC_NSR<4> VSS JNWATR_NCH_4C1F2
xca7<4> VC_NSR<4> VCN VC_NSR<3> VSS JNWATR_NCH_4C1F2
xca7<3> VC_NSR<3> VCN VC_NSR<2> VSS JNWATR_NCH_4C1F2
xca7<2> VC_NSR<2> VCN VC_NSR<1> VSS JNWATR_NCH_4C1F2
xca7<1> VC_NSR<1> VCN VC_NSR<0> VSS JNWATR_NCH_4C1F2
xca7<0> VC_NSR<0> VCN VSS VSS JNWATR_NCH_4C1F2
xd1 VS2 net6 VS2 JNWTR_RPPO2
xca8 net6 PWRUP_1V8 VSS VSS JNWATR_NCH_4C5F0
xba10 VO PWRUP_1V8 VDD_1V8 VDD_1V8 JNWATR_PCH_12C5F0
xd3 net7 VS VSS JNWTR_RPPO2
.ends

* expanding   symbol:  JNW_TR_SKY130A/JNWTR_RPPO4.sym # of pins=3
** sym_path: /Users/wulff/data/2023/aicex/ip/lelo_temp_sky130a/design/JNW_TR_SKY130A/JNWTR_RPPO4.sym
** sch_path: /Users/wulff/data/2023/aicex/ip/lelo_temp_sky130a/design/JNW_TR_SKY130A/JNWTR_RPPO4.sch
.subckt JNWTR_RPPO4 N P B
*.iopin P
*.iopin N
*.iopin B
XXA1 N P B JNWTR_RES4
.ends

* expanding   symbol:  JNW_BIAS_SKY130A/JNWBIAS_BIPOLAR.sym # of pins=3
** sym_path: /Users/wulff/data/2023/aicex/ip/lelo_temp_sky130a/design/JNW_BIAS_SKY130A/JNWBIAS_BIPOLAR.sym
** sch_path: /Users/wulff/data/2023/aicex/ip/lelo_temp_sky130a/design/JNW_BIAS_SKY130A/JNWBIAS_BIPOLAR.sch
.subckt JNWBIAS_BIPOLAR VD2 VD1 VSS
*.ipin VSS
*.ipin VD1
*.ipin VD2
XQ1 VSS VSS VD1 sky130_fd_pr__pnp_05v5_W3p40L3p40 m=1 mult=1
XQ2<7> VSS VSS VD2 sky130_fd_pr__pnp_05v5_W3p40L3p40 m=1 mult=1
XQ2<6> VSS VSS VD2 sky130_fd_pr__pnp_05v5_W3p40L3p40 m=1 mult=1
XQ2<5> VSS VSS VD2 sky130_fd_pr__pnp_05v5_W3p40L3p40 m=1 mult=1
XQ2<4> VSS VSS VD2 sky130_fd_pr__pnp_05v5_W3p40L3p40 m=1 mult=1
XQ2<3> VSS VSS VD2 sky130_fd_pr__pnp_05v5_W3p40L3p40 m=1 mult=1
XQ2<2> VSS VSS VD2 sky130_fd_pr__pnp_05v5_W3p40L3p40 m=1 mult=1
XQ2<1> VSS VSS VD2 sky130_fd_pr__pnp_05v5_W3p40L3p40 m=1 mult=1
XQ2<0> VSS VSS VD2 sky130_fd_pr__pnp_05v5_W3p40L3p40 m=1 mult=1
.ends

* expanding   symbol:  JNW_ATR_SKY130A/JNWATR_NCH_4C5F0.sym # of pins=4
** sym_path: /Users/wulff/data/2023/aicex/ip/lelo_temp_sky130a/design/JNW_ATR_SKY130A/JNWATR_NCH_4C5F0.sym
** sch_path: /Users/wulff/data/2023/aicex/ip/lelo_temp_sky130a/design/JNW_ATR_SKY130A/JNWATR_NCH_4C5F0.sch
.subckt JNWATR_NCH_4C5F0 D G S B
*.iopin D
*.iopin G
*.iopin S
*.iopin B
XM1 D G S B sky130_fd_pr__nfet_01v8 L=0.94 W=3.2 nf=2 ad='int((nf+1)/2) * W/nf * 0.29' as='int((nf+2)/2) * W/nf * 0.29' pd='2*int((nf+1)/2) * (W/nf + 0.29)'
+ ps='2*int((nf+2)/2) * (W/nf + 0.29)' nrd='0.29 / W' nrs='0.29 / W' sa=0 sb=0 sd=0 mult=1 m=1
.ends

* expanding   symbol:  JNW_TR_SKY130A/JNWTR_RPPO8.sym # of pins=3
** sym_path: /Users/wulff/data/2023/aicex/ip/lelo_temp_sky130a/design/JNW_TR_SKY130A/JNWTR_RPPO8.sym
** sch_path: /Users/wulff/data/2023/aicex/ip/lelo_temp_sky130a/design/JNW_TR_SKY130A/JNWTR_RPPO8.sch
.subckt JNWTR_RPPO8 N P B
*.iopin P
*.iopin N
*.iopin B
XXA1 N P B JNWTR_RES8
.ends

* expanding   symbol:  JNW_ATR_SKY130A/JNWATR_PCH_4C1F2.sym # of pins=4
** sym_path: /Users/wulff/data/2023/aicex/ip/lelo_temp_sky130a/design/JNW_ATR_SKY130A/JNWATR_PCH_4C1F2.sym
** sch_path: /Users/wulff/data/2023/aicex/ip/lelo_temp_sky130a/design/JNW_ATR_SKY130A/JNWATR_PCH_4C1F2.sch
.subckt JNWATR_PCH_4C1F2 D G S B
*.iopin D
*.iopin G
*.iopin S
*.iopin B
XM1 D G S B sky130_fd_pr__pfet_01v8 L=0.22 W=3.2 nf=2 ad='int((nf+1)/2) * W/nf * 0.29' as='int((nf+2)/2) * W/nf * 0.29' pd='2*int((nf+1)/2) * (W/nf + 0.29)'
+ ps='2*int((nf+2)/2) * (W/nf + 0.29)' nrd='0.29 / W' nrs='0.29 / W' sa=0 sb=0 sd=0 mult=1 m=1
.ends

* expanding   symbol:  LELO_ATR_SKY130A/LELOATR_LVT_NCH_4C5F0.sym # of pins=4
** sym_path: /Users/wulff/data/2023/aicex/ip/lelo_temp_sky130a/design/LELO_ATR_SKY130A/LELOATR_LVT_NCH_4C5F0.sym
** sch_path: /Users/wulff/data/2023/aicex/ip/lelo_temp_sky130a/design/LELO_ATR_SKY130A/LELOATR_LVT_NCH_4C5F0.sch
.subckt LELOATR_LVT_NCH_4C5F0 D G S B
*.iopin D
*.iopin G
*.iopin S
*.iopin B
XM1 D G S B sky130_fd_pr__nfet_01v8_lvt L=0.94 W=3.2 nf=2 ad='int((nf+1)/2) * W/nf * 0.29' as='int((nf+2)/2) * W/nf * 0.29' pd='2*int((nf+1)/2) * (W/nf + 0.29)'
+ ps='2*int((nf+2)/2) * (W/nf + 0.29)' nrd='0.29 / W' nrs='0.29 / W' sa=0 sb=0 sd=0 mult=1 m=1
.ends

* expanding   symbol:  JNW_ATR_SKY130A/JNWATR_NCH_4C1F2.sym # of pins=4
** sym_path: /Users/wulff/data/2023/aicex/ip/lelo_temp_sky130a/design/JNW_ATR_SKY130A/JNWATR_NCH_4C1F2.sym
** sch_path: /Users/wulff/data/2023/aicex/ip/lelo_temp_sky130a/design/JNW_ATR_SKY130A/JNWATR_NCH_4C1F2.sch
.subckt JNWATR_NCH_4C1F2 D G S B
*.iopin D
*.iopin G
*.iopin S
*.iopin B
XM1 D G S B sky130_fd_pr__nfet_01v8 L=0.22 W=3.2 nf=2 ad='int((nf+1)/2) * W/nf * 0.29' as='int((nf+2)/2) * W/nf * 0.29' pd='2*int((nf+1)/2) * (W/nf + 0.29)'
+ ps='2*int((nf+2)/2) * (W/nf + 0.29)' nrd='0.29 / W' nrs='0.29 / W' sa=0 sb=0 sd=0 mult=1 m=1
.ends

* expanding   symbol:  JNW_ATR_SKY130A/JNWATR_PCH_12C5F0.sym # of pins=4
** sym_path: /Users/wulff/data/2023/aicex/ip/lelo_temp_sky130a/design/JNW_ATR_SKY130A/JNWATR_PCH_12C5F0.sym
** sch_path: /Users/wulff/data/2023/aicex/ip/lelo_temp_sky130a/design/JNW_ATR_SKY130A/JNWATR_PCH_12C5F0.sch
.subckt JNWATR_PCH_12C5F0 D G S B
*.iopin D
*.iopin G
*.iopin S
*.iopin B
XM1 D G S B sky130_fd_pr__pfet_01v8 L=0.94 W=8.32 nf=2 ad='int((nf+1)/2) * W/nf * 0.29' as='int((nf+2)/2) * W/nf * 0.29' pd='2*int((nf+1)/2) * (W/nf + 0.29)'
+ ps='2*int((nf+2)/2) * (W/nf + 0.29)' nrd='0.29 / W' nrs='0.29 / W' sa=0 sb=0 sd=0 mult=1 m=1
.ends

* expanding   symbol:  JNW_TR_SKY130A/JNWTR_RPPO2.sym # of pins=3
** sym_path: /Users/wulff/data/2023/aicex/ip/lelo_temp_sky130a/design/JNW_TR_SKY130A/JNWTR_RPPO2.sym
** sch_path: /Users/wulff/data/2023/aicex/ip/lelo_temp_sky130a/design/JNW_TR_SKY130A/JNWTR_RPPO2.sch
.subckt JNWTR_RPPO2 N P B
*.iopin P
*.iopin N
*.iopin B
XXA1 N P B JNWTR_RES2
.ends

* expanding   symbol:  JNW_TR_SKY130A/JNWTR_RES4.sym # of pins=3
** sym_path: /Users/wulff/data/2023/aicex/ip/lelo_temp_sky130a/design/JNW_TR_SKY130A/JNWTR_RES4.sym
** sch_path: /Users/wulff/data/2023/aicex/ip/lelo_temp_sky130a/design/JNW_TR_SKY130A/JNWTR_RES4.sch
.subckt JNWTR_RES4 N P B
*.iopin N
*.iopin P
*.iopin B
XR1_0 INT_0 N B sky130_fd_pr__res_high_po W=0.36 L=7.36 mult=1 m=1
XR1_1 INT_1 INT_0 B sky130_fd_pr__res_high_po W=0.36 L=7.36 mult=1 m=1
XR1_2 INT_2 INT_1 B sky130_fd_pr__res_high_po W=0.36 L=7.36 mult=1 m=1
XR1_3 P INT_2 B sky130_fd_pr__res_high_po W=0.36 L=7.36 mult=1 m=1
.ends

* expanding   symbol:  JNW_TR_SKY130A/JNWTR_RES8.sym # of pins=3
** sym_path: /Users/wulff/data/2023/aicex/ip/lelo_temp_sky130a/design/JNW_TR_SKY130A/JNWTR_RES8.sym
** sch_path: /Users/wulff/data/2023/aicex/ip/lelo_temp_sky130a/design/JNW_TR_SKY130A/JNWTR_RES8.sch
.subckt JNWTR_RES8 N P B
*.iopin N
*.iopin P
*.iopin B
XR1_0 INT_0 N B sky130_fd_pr__res_high_po W=0.36 L=7.36 mult=1 m=1
XR1_1 INT_1 INT_0 B sky130_fd_pr__res_high_po W=0.36 L=7.36 mult=1 m=1
XR1_2 INT_2 INT_1 B sky130_fd_pr__res_high_po W=0.36 L=7.36 mult=1 m=1
XR1_3 INT_3 INT_2 B sky130_fd_pr__res_high_po W=0.36 L=7.36 mult=1 m=1
XR1_4 INT_4 INT_3 B sky130_fd_pr__res_high_po W=0.36 L=7.36 mult=1 m=1
XR1_5 INT_5 INT_4 B sky130_fd_pr__res_high_po W=0.36 L=7.36 mult=1 m=1
XR1_6 INT_6 INT_5 B sky130_fd_pr__res_high_po W=0.36 L=7.36 mult=1 m=1
XR1_7 P INT_6 B sky130_fd_pr__res_high_po W=0.36 L=7.36 mult=1 m=1
.ends

* expanding   symbol:  JNW_TR_SKY130A/JNWTR_RES2.sym # of pins=3
** sym_path: /Users/wulff/data/2023/aicex/ip/lelo_temp_sky130a/design/JNW_TR_SKY130A/JNWTR_RES2.sym
** sch_path: /Users/wulff/data/2023/aicex/ip/lelo_temp_sky130a/design/JNW_TR_SKY130A/JNWTR_RES2.sch
.subckt JNWTR_RES2 N P B
*.iopin N
*.iopin P
*.iopin B
XR1_0 INT_0 N B sky130_fd_pr__res_high_po W=0.36 L=7.36 mult=1 m=1
XR1_1 P INT_0 B sky130_fd_pr__res_high_po W=0.36 L=7.36 mult=1 m=1
.ends

.end
