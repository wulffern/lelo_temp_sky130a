** sch_path: /Users/wulff/data/2023/aicex/ip/lelo_temp_sky130a/design/LELO_TEMP_SKY130A/LELOTEMP_CASCBIAS.sch
**.subckt LELOTEMP_CASCBIAS VDD_1V8 PWRUP_1V8 VCN VCP VBP1 VBP2 PWRUP_N_1V8 VSS
*.opin VCP
*.ipin VDD_1V8
*.ipin VSS
*.ipin PWRUP_N_1V8
*.ipin PWRUP_1V8
*.opin VCN
*.ipin VBP1
*.ipin VBP2
xbb3<5> VC_SER<4> VCP VDD_1V8 VDD_1V8 JNWATR_PCH_4C1F2
xbb3<4> VC_SER<3> VCP VC_SER<4> VDD_1V8 JNWATR_PCH_4C1F2
xbb3<3> VC_SER<2> VCP VC_SER<3> VDD_1V8 JNWATR_PCH_4C1F2
xbb3<2> VC_SER<1> VCP VC_SER<2> VDD_1V8 JNWATR_PCH_4C1F2
xbb3<1> VC_SER<0> VCP VC_SER<1> VDD_1V8 JNWATR_PCH_4C1F2
xbb3<0> VCP VCP VC_SER<0> VDD_1V8 JNWATR_PCH_4C1F2
xca7<5> VCN VCN VC_NSR<4> VSS JNWATR_NCH_4C1F2
xca7<4> VC_NSR<4> VCN VC_NSR<3> VSS JNWATR_NCH_4C1F2
xca7<3> VC_NSR<3> VCN VC_NSR<2> VSS JNWATR_NCH_4C1F2
xca7<2> VC_NSR<2> VCN VC_NSR<1> VSS JNWATR_NCH_4C1F2
xca7<1> VC_NSR<1> VCN VC_NSR<0> VSS JNWATR_NCH_4C1F2
xca7<0> VC_NSR<0> VCN VSS VSS JNWATR_NCH_4C1F2
xca8 VBNT PWRUP_N_1V8 VSS VSS JNWATR_NCH_4C5F0
xba1 VBNT VBP1 VDD_1V8 VDD_1V8 JNWATR_PCH_4C5F0
xca7 VBNT VBNT VSS VSS JNWATR_NCH_4C5F0
xba5<3> VCN net1 VDD_1V8 VDD_1V8 JNWATR_PCH_4C5F0
xba5<2> VCN net1 VDD_1V8 VDD_1V8 JNWATR_PCH_4C5F0
xba5<1> VCN net1 VDD_1V8 VDD_1V8 JNWATR_PCH_4C5F0
xba5<0> VCN net1 VDD_1V8 VDD_1V8 JNWATR_PCH_4C5F0
xca15<1> VCP VBNT VSS VSS JNWATR_NCH_4C5F0
xca15<0> VCP VBNT VSS VSS JNWATR_NCH_4C5F0
xba2 VBNT VBP2 VDD_1V8 VDD_1V8 JNWATR_PCH_4C5F0
xba9 net1 net1 VDD_1V8 VDD_1V8 JNWATR_PCH_4C5F0
xca5 net1 VBNT VSS VSS JNWATR_NCH_4C5F0
xba15 net1 PWRUP_1V8 VDD_1V8 VDD_1V8 JNWATR_PCH_12C5F0
xba16 VCP PWRUP_1V8 VDD_1V8 VDD_1V8 JNWATR_PCH_4C5F0
xca19 VCN PWRUP_N_1V8 VSS VSS JNWATR_NCH_4C5F0
xbb4 VDD_1V8 VCP VDD_1V8 VDD_1V8 JNWATR_PCH_12C5F0
x2 VSS VCN VSS VSS LELOATR_PCH_12C5F0
x3 VSS VBNT VSS VSS LELOATR_PCH_12C5F0
**.ends

* expanding   symbol:  JNW_ATR_SKY130A/JNWATR_PCH_4C1F2.sym # of pins=4
** sym_path: /Users/wulff/data/2023/aicex/ip/lelo_temp_sky130a/design/JNW_ATR_SKY130A/JNWATR_PCH_4C1F2.sym
** sch_path: /Users/wulff/data/2023/aicex/ip/lelo_temp_sky130a/design/JNW_ATR_SKY130A/JNWATR_PCH_4C1F2.sch
.subckt JNWATR_PCH_4C1F2 D G S B
*.iopin D
*.iopin G
*.iopin S
*.iopin B
XM1 D G S B sky130_fd_pr__pfet_01v8 L=0.22 W=3.2 nf=2 ad='int((nf+1)/2) * W/nf * 0.29' as='int((nf+2)/2) * W/nf * 0.29' pd='2*int((nf+1)/2) * (W/nf + 0.29)'
+ ps='2*int((nf+2)/2) * (W/nf + 0.29)' nrd='0.29 / W' nrs='0.29 / W' sa=0 sb=0 sd=0 mult=1 m=1
.ends

* expanding   symbol:  JNW_ATR_SKY130A/JNWATR_NCH_4C1F2.sym # of pins=4
** sym_path: /Users/wulff/data/2023/aicex/ip/lelo_temp_sky130a/design/JNW_ATR_SKY130A/JNWATR_NCH_4C1F2.sym
** sch_path: /Users/wulff/data/2023/aicex/ip/lelo_temp_sky130a/design/JNW_ATR_SKY130A/JNWATR_NCH_4C1F2.sch
.subckt JNWATR_NCH_4C1F2 D G S B
*.iopin D
*.iopin G
*.iopin S
*.iopin B
XM1 D G S B sky130_fd_pr__nfet_01v8 L=0.22 W=3.2 nf=2 ad='int((nf+1)/2) * W/nf * 0.29' as='int((nf+2)/2) * W/nf * 0.29' pd='2*int((nf+1)/2) * (W/nf + 0.29)'
+ ps='2*int((nf+2)/2) * (W/nf + 0.29)' nrd='0.29 / W' nrs='0.29 / W' sa=0 sb=0 sd=0 mult=1 m=1
.ends

* expanding   symbol:  JNW_ATR_SKY130A/JNWATR_NCH_4C5F0.sym # of pins=4
** sym_path: /Users/wulff/data/2023/aicex/ip/lelo_temp_sky130a/design/JNW_ATR_SKY130A/JNWATR_NCH_4C5F0.sym
** sch_path: /Users/wulff/data/2023/aicex/ip/lelo_temp_sky130a/design/JNW_ATR_SKY130A/JNWATR_NCH_4C5F0.sch
.subckt JNWATR_NCH_4C5F0 D G S B
*.iopin D
*.iopin G
*.iopin S
*.iopin B
XM1 D G S B sky130_fd_pr__nfet_01v8 L=0.94 W=3.2 nf=2 ad='int((nf+1)/2) * W/nf * 0.29' as='int((nf+2)/2) * W/nf * 0.29' pd='2*int((nf+1)/2) * (W/nf + 0.29)'
+ ps='2*int((nf+2)/2) * (W/nf + 0.29)' nrd='0.29 / W' nrs='0.29 / W' sa=0 sb=0 sd=0 mult=1 m=1
.ends

* expanding   symbol:  JNW_ATR_SKY130A/JNWATR_PCH_4C5F0.sym # of pins=4
** sym_path: /Users/wulff/data/2023/aicex/ip/lelo_temp_sky130a/design/JNW_ATR_SKY130A/JNWATR_PCH_4C5F0.sym
** sch_path: /Users/wulff/data/2023/aicex/ip/lelo_temp_sky130a/design/JNW_ATR_SKY130A/JNWATR_PCH_4C5F0.sch
.subckt JNWATR_PCH_4C5F0 D G S B
*.iopin D
*.iopin G
*.iopin S
*.iopin B
XM1 D G S B sky130_fd_pr__pfet_01v8 L=0.94 W=3.2 nf=2 ad='int((nf+1)/2) * W/nf * 0.29' as='int((nf+2)/2) * W/nf * 0.29' pd='2*int((nf+1)/2) * (W/nf + 0.29)'
+ ps='2*int((nf+2)/2) * (W/nf + 0.29)' nrd='0.29 / W' nrs='0.29 / W' sa=0 sb=0 sd=0 mult=1 m=1
.ends

* expanding   symbol:  JNW_ATR_SKY130A/JNWATR_PCH_12C5F0.sym # of pins=4
** sym_path: /Users/wulff/data/2023/aicex/ip/lelo_temp_sky130a/design/JNW_ATR_SKY130A/JNWATR_PCH_12C5F0.sym
** sch_path: /Users/wulff/data/2023/aicex/ip/lelo_temp_sky130a/design/JNW_ATR_SKY130A/JNWATR_PCH_12C5F0.sch
.subckt JNWATR_PCH_12C5F0 D G S B
*.iopin D
*.iopin G
*.iopin S
*.iopin B
XM1 D G S B sky130_fd_pr__pfet_01v8 L=0.94 W=8.32 nf=2 ad='int((nf+1)/2) * W/nf * 0.29' as='int((nf+2)/2) * W/nf * 0.29' pd='2*int((nf+1)/2) * (W/nf + 0.29)'
+ ps='2*int((nf+2)/2) * (W/nf + 0.29)' nrd='0.29 / W' nrs='0.29 / W' sa=0 sb=0 sd=0 mult=1 m=1
.ends

* expanding   symbol:  LELO_ATR_SKY130A/LELOATR_PCH_12C5F0.sym # of pins=4
** sym_path: /Users/wulff/data/2023/aicex/ip/lelo_temp_sky130a/design/LELO_ATR_SKY130A/LELOATR_PCH_12C5F0.sym
** sch_path: /Users/wulff/data/2023/aicex/ip/lelo_temp_sky130a/design/LELO_ATR_SKY130A/LELOATR_PCH_12C5F0.sch
.subckt LELOATR_PCH_12C5F0 D G S B
*.iopin D
*.iopin G
*.iopin S
*.iopin B
XM1 D G S B sky130_fd_pr__pfet_01v8 L=0.94 W=8.32 nf=2 ad='int((nf+1)/2) * W/nf * 0.29' as='int((nf+2)/2) * W/nf * 0.29' pd='2*int((nf+1)/2) * (W/nf + 0.29)'
+ ps='2*int((nf+2)/2) * (W/nf + 0.29)' nrd='0.29 / W' nrs='0.29 / W' sa=0 sb=0 sd=0 mult=1 m=1
.ends

.end
