** sch_path: /Users/wulff/data/2023/aicex/ip/lelo_temp_sky130a/design/LELO_TEMP_SKY130A/LELOTEMP_OTA.sch
**.subckt LELOTEMP_OTA VDD_1V8 VIP VO VIN VSS PWRUP_1V8 PWRUP_N_1V8 VCP
*.opin VO
*.ipin VIP
*.ipin VIN
*.ipin VDD_1V8
*.ipin VSS
*.ipin PWRUP_N_1V8
*.ipin PWRUP_1V8
*.opin VCP
xba1<7> VD1 VIN VS VDD_1V8 JNWATR_PCH_12C1F2
xba1<6> VD1 VIN VS VDD_1V8 JNWATR_PCH_12C1F2
xba1<5> VD1 VIN VS VDD_1V8 JNWATR_PCH_12C1F2
xba1<4> VD1 VIN VS VDD_1V8 JNWATR_PCH_12C1F2
xba1<3> VD1 VIN VS VDD_1V8 JNWATR_PCH_12C1F2
xba1<2> VD1 VIN VS VDD_1V8 JNWATR_PCH_12C1F2
xba1<1> VD1 VIN VS VDD_1V8 JNWATR_PCH_12C1F2
xba1<0> VD1 VIN VS VDD_1V8 JNWATR_PCH_12C1F2
xbb2<7> VD2 VIP VS VDD_1V8 JNWATR_PCH_12C1F2
xbb2<6> VD2 VIP VS VDD_1V8 JNWATR_PCH_12C1F2
xbb2<5> VD2 VIP VS VDD_1V8 JNWATR_PCH_12C1F2
xbb2<4> VD2 VIP VS VDD_1V8 JNWATR_PCH_12C1F2
xbb2<3> VD2 VIP VS VDD_1V8 JNWATR_PCH_12C1F2
xbb2<2> VD2 VIP VS VDD_1V8 JNWATR_PCH_12C1F2
xbb2<1> VD2 VIP VS VDD_1V8 JNWATR_PCH_12C1F2
xbb2<0> VD2 VIP VS VDD_1V8 JNWATR_PCH_12C1F2
xca1<3> VD1 VD1 VSS VSS JNWATR_NCH_4C5F0
xca1<2> VD1 VD1 VSS VSS JNWATR_NCH_4C5F0
xca1<1> VD1 VD1 VSS VSS JNWATR_NCH_4C5F0
xca1<0> VD1 VD1 VSS VSS JNWATR_NCH_4C5F0
xcb2<3> VD2 VD2 VSS VSS JNWATR_NCH_4C5F0
xcb2<2> VD2 VD2 VSS VSS JNWATR_NCH_4C5F0
xcb2<1> VD2 VD2 VSS VSS JNWATR_NCH_4C5F0
xcb2<0> VD2 VD2 VSS VSS JNWATR_NCH_4C5F0
xba6 net1 net1 VDD_1V8 VDD_1V8 JNWATR_PCH_12C5F0
xca3 net1 VD1 VSS VSS JNWATR_NCH_4C5F0
xbb3 VO net1 VDD_1V8 VDD_1V8 JNWATR_PCH_12C5F0
xcb4 VO VD2 VSS VSS JNWATR_NCH_4C5F0
xd2 net2 VS VSS JNWTR_RPPO2
xba7 net1 PWRUP_1V8 VDD_1V8 VDD_1V8 JNWATR_PCH_12C5F0
xba1 net2 PWRUP_N_1V8 VDD_1V8 VDD_1V8 JNWATR_PCH_12C5F0
xba2 VO PWRUP_1V8 VDD_1V8 VDD_1V8 JNWATR_PCH_12C5F0
xca1 VD1 PWRUP_N_1V8 VSS VSS JNWATR_NCH_4C5F0
xca2 VD2 PWRUP_N_1V8 VSS VSS JNWATR_NCH_4C5F0
xba4 net3 VIN VS VDD_1V8 JNWATR_PCH_12C1F2
xbb5 net3 VIP VS VDD_1V8 JNWATR_PCH_12C1F2
xcb1 net3 net3 VSS VSS JNWATR_NCH_4C5F0
xcb2 VCP net3 VSS VSS JNWATR_NCH_4C5F0
xbb6 VCP VCP VDD_1V8 VDD_1V8 JNWATR_PCH_4C5F0
**.ends

* expanding   symbol:  JNW_ATR_SKY130A/JNWATR_PCH_12C1F2.sym # of pins=4
** sym_path: /Users/wulff/data/2023/aicex/ip/lelo_temp_sky130a/design/JNW_ATR_SKY130A/JNWATR_PCH_12C1F2.sym
** sch_path: /Users/wulff/data/2023/aicex/ip/lelo_temp_sky130a/design/JNW_ATR_SKY130A/JNWATR_PCH_12C1F2.sch
.subckt JNWATR_PCH_12C1F2 D G S B
*.iopin D
*.iopin G
*.iopin S
*.iopin B
XM1 D G S B sky130_fd_pr__pfet_01v8 L=0.22 W=8.32 nf=2 ad='int((nf+1)/2) * W/nf * 0.29' as='int((nf+2)/2) * W/nf * 0.29' pd='2*int((nf+1)/2) * (W/nf + 0.29)'
+ ps='2*int((nf+2)/2) * (W/nf + 0.29)' nrd='0.29 / W' nrs='0.29 / W' sa=0 sb=0 sd=0 mult=1 m=1
.ends

* expanding   symbol:  JNW_ATR_SKY130A/JNWATR_NCH_4C5F0.sym # of pins=4
** sym_path: /Users/wulff/data/2023/aicex/ip/lelo_temp_sky130a/design/JNW_ATR_SKY130A/JNWATR_NCH_4C5F0.sym
** sch_path: /Users/wulff/data/2023/aicex/ip/lelo_temp_sky130a/design/JNW_ATR_SKY130A/JNWATR_NCH_4C5F0.sch
.subckt JNWATR_NCH_4C5F0 D G S B
*.iopin D
*.iopin G
*.iopin S
*.iopin B
XM1 D G S B sky130_fd_pr__nfet_01v8 L=0.94 W=3.2 nf=2 ad='int((nf+1)/2) * W/nf * 0.29' as='int((nf+2)/2) * W/nf * 0.29' pd='2*int((nf+1)/2) * (W/nf + 0.29)'
+ ps='2*int((nf+2)/2) * (W/nf + 0.29)' nrd='0.29 / W' nrs='0.29 / W' sa=0 sb=0 sd=0 mult=1 m=1
.ends

* expanding   symbol:  JNW_ATR_SKY130A/JNWATR_PCH_12C5F0.sym # of pins=4
** sym_path: /Users/wulff/data/2023/aicex/ip/lelo_temp_sky130a/design/JNW_ATR_SKY130A/JNWATR_PCH_12C5F0.sym
** sch_path: /Users/wulff/data/2023/aicex/ip/lelo_temp_sky130a/design/JNW_ATR_SKY130A/JNWATR_PCH_12C5F0.sch
.subckt JNWATR_PCH_12C5F0 D G S B
*.iopin D
*.iopin G
*.iopin S
*.iopin B
XM1 D G S B sky130_fd_pr__pfet_01v8 L=0.94 W=8.32 nf=2 ad='int((nf+1)/2) * W/nf * 0.29' as='int((nf+2)/2) * W/nf * 0.29' pd='2*int((nf+1)/2) * (W/nf + 0.29)'
+ ps='2*int((nf+2)/2) * (W/nf + 0.29)' nrd='0.29 / W' nrs='0.29 / W' sa=0 sb=0 sd=0 mult=1 m=1
.ends

* expanding   symbol:  JNW_TR_SKY130A/JNWTR_RPPO2.sym # of pins=3
** sym_path: /Users/wulff/data/2023/aicex/ip/lelo_temp_sky130a/design/JNW_TR_SKY130A/JNWTR_RPPO2.sym
** sch_path: /Users/wulff/data/2023/aicex/ip/lelo_temp_sky130a/design/JNW_TR_SKY130A/JNWTR_RPPO2.sch
.subckt JNWTR_RPPO2 N P B
*.iopin P
*.iopin N
*.iopin B
XXA1 N P B JNWTR_RES2
.ends

* expanding   symbol:  JNW_ATR_SKY130A/JNWATR_PCH_4C5F0.sym # of pins=4
** sym_path: /Users/wulff/data/2023/aicex/ip/lelo_temp_sky130a/design/JNW_ATR_SKY130A/JNWATR_PCH_4C5F0.sym
** sch_path: /Users/wulff/data/2023/aicex/ip/lelo_temp_sky130a/design/JNW_ATR_SKY130A/JNWATR_PCH_4C5F0.sch
.subckt JNWATR_PCH_4C5F0 D G S B
*.iopin D
*.iopin G
*.iopin S
*.iopin B
XM1 D G S B sky130_fd_pr__pfet_01v8 L=0.94 W=3.2 nf=2 ad='int((nf+1)/2) * W/nf * 0.29' as='int((nf+2)/2) * W/nf * 0.29' pd='2*int((nf+1)/2) * (W/nf + 0.29)'
+ ps='2*int((nf+2)/2) * (W/nf + 0.29)' nrd='0.29 / W' nrs='0.29 / W' sa=0 sb=0 sd=0 mult=1 m=1
.ends

* expanding   symbol:  JNW_TR_SKY130A/JNWTR_RES2.sym # of pins=3
** sym_path: /Users/wulff/data/2023/aicex/ip/lelo_temp_sky130a/design/JNW_TR_SKY130A/JNWTR_RES2.sym
** sch_path: /Users/wulff/data/2023/aicex/ip/lelo_temp_sky130a/design/JNW_TR_SKY130A/JNWTR_RES2.sch
.subckt JNWTR_RES2 N P B
*.iopin N
*.iopin P
*.iopin B
XR1_0 INT_0 N B sky130_fd_pr__res_high_po W=0.36 L=7.36 mult=1 m=1
XR1_1 P INT_0 B sky130_fd_pr__res_high_po W=0.36 L=7.36 mult=1 m=1
.ends

.end
