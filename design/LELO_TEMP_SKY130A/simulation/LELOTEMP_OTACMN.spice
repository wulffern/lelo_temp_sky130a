** sch_path: /Users/wulff/data/2023/aicex/ip/lelo_temp_sky130a/design/LELO_TEMP_SKY130A/LELOTEMP_OTACMN.sch
**.subckt LELOTEMP_OTACMN VDD_1V8 PWRUP_1V8 VCP VO VCN PWRUP_N_1V8 VIN VIP VSS VBP1 VBP2
*.ipin VDD_1V8
*.ipin VSS
*.ipin PWRUP_N_1V8
*.ipin PWRUP_1V8
*.opin VO
*.ipin VIP
*.ipin VIN
*.ipin VCP
*.ipin VCN
*.opin VBP2
*.opin VBP1
xca3 VDN2 VBN VSS VSS JNWATR_NCH_4C5F0
xbb1<7> VBP2 VIN VS VSS LELOATR_LVT_NCH_4C5F0
xbb1<6> VBP2 VIN VS VSS LELOATR_LVT_NCH_4C5F0
xbb1<5> VBP2 VIN VS VSS LELOATR_LVT_NCH_4C5F0
xbb1<4> VBP2 VIN VS VSS LELOATR_LVT_NCH_4C5F0
xbb1<3> VBP2 VIN VS VSS LELOATR_LVT_NCH_4C5F0
xbb1<2> VBP2 VIN VS VSS LELOATR_LVT_NCH_4C5F0
xbb1<1> VBP2 VIN VS VSS LELOATR_LVT_NCH_4C5F0
xbb1<0> VBP2 VIN VS VSS LELOATR_LVT_NCH_4C5F0
xbb2<7> VBP1 VIP VS VSS LELOATR_LVT_NCH_4C5F0
xbb2<6> VBP1 VIP VS VSS LELOATR_LVT_NCH_4C5F0
xbb2<5> VBP1 VIP VS VSS LELOATR_LVT_NCH_4C5F0
xbb2<4> VBP1 VIP VS VSS LELOATR_LVT_NCH_4C5F0
xbb2<3> VBP1 VIP VS VSS LELOATR_LVT_NCH_4C5F0
xbb2<2> VBP1 VIP VS VSS LELOATR_LVT_NCH_4C5F0
xbb2<1> VBP1 VIP VS VSS LELOATR_LVT_NCH_4C5F0
xbb2<0> VBP1 VIP VS VSS LELOATR_LVT_NCH_4C5F0
xba2<3> net3<3> VBP2 VDD_1V8 VDD_1V8 JNWATR_PCH_4C5F0
xba2<2> net3<2> VBP2 VDD_1V8 VDD_1V8 JNWATR_PCH_4C5F0
xba2<1> net3<1> VBP2 VDD_1V8 VDD_1V8 JNWATR_PCH_4C5F0
xba2<0> net3<0> VBP2 VDD_1V8 VDD_1V8 JNWATR_PCH_4C5F0
xba14<3> net1<3> VBP1 VDD_1V8 VDD_1V8 JNWATR_PCH_4C5F0
xba14<2> net1<2> VBP1 VDD_1V8 VDD_1V8 JNWATR_PCH_4C5F0
xba14<1> net1<1> VBP1 VDD_1V8 VDD_1V8 JNWATR_PCH_4C5F0
xba14<0> net1<0> VBP1 VDD_1V8 VDD_1V8 JNWATR_PCH_4C5F0
xba5 net2 VBP1 VDD_1V8 VDD_1V8 JNWATR_PCH_4C5F0
xba8 VDN1 VBP2 VDD_1V8 VDD_1V8 JNWATR_PCH_4C5F0
xca4 net4 VBN VSS VSS JNWATR_NCH_4C5F0
xba6 VBP2 PWRUP_1V8 VDD_1V8 VDD_1V8 JNWATR_PCH_4C5F0
xba11 VBP1 PWRUP_1V8 VDD_1V8 VDD_1V8 JNWATR_PCH_4C5F0
xca6 VBN PWRUP_N_1V8 VSS VSS JNWATR_NCH_4C5F0
xba10 VO PWRUP_1V8 VDD_1V8 VDD_1V8 JNWATR_PCH_4C5F0
xca1<3> net5 PWRUP_1V8 VSS VSS JNWATR_NCH_4C5F0
xca1<2> net5 PWRUP_1V8 VSS VSS JNWATR_NCH_4C5F0
xca1<1> net5 PWRUP_1V8 VSS VSS JNWATR_NCH_4C5F0
xca1<0> net5 PWRUP_1V8 VSS VSS JNWATR_NCH_4C5F0
xba7 VBN VCP VDN1 VDD_1V8 JNWATR_PCH_4C1F2
xca1 VBN VCN VDN2 VSS JNWATR_NCH_4C1F2
xca2 VO VCN net4 VSS JNWATR_NCH_4C1F2
xba9<3> VBP2 VCP net3<3> VDD_1V8 JNWATR_PCH_4C1F2
xba9<2> VBP2 VCP net3<2> VDD_1V8 JNWATR_PCH_4C1F2
xba9<1> VBP2 VCP net3<1> VDD_1V8 JNWATR_PCH_4C1F2
xba9<0> VBP2 VCP net3<0> VDD_1V8 JNWATR_PCH_4C1F2
xba12<3> VBP1 VCP net1<3> VDD_1V8 JNWATR_PCH_4C1F2
xba12<2> VBP1 VCP net1<2> VDD_1V8 JNWATR_PCH_4C1F2
xba12<1> VBP1 VCP net1<1> VDD_1V8 JNWATR_PCH_4C1F2
xba12<0> VBP1 VCP net1<0> VDD_1V8 JNWATR_PCH_4C1F2
xba13 VO VCP net2 VDD_1V8 JNWATR_PCH_4C1F2
x1 VS net5 VSS JNWTR_RPPO4
**.ends

* expanding   symbol:  JNW_ATR_SKY130A/JNWATR_NCH_4C5F0.sym # of pins=4
** sym_path: /Users/wulff/data/2023/aicex/ip/lelo_temp_sky130a/design/JNW_ATR_SKY130A/JNWATR_NCH_4C5F0.sym
** sch_path: /Users/wulff/data/2023/aicex/ip/lelo_temp_sky130a/design/JNW_ATR_SKY130A/JNWATR_NCH_4C5F0.sch
.subckt JNWATR_NCH_4C5F0 D G S B
*.iopin D
*.iopin G
*.iopin S
*.iopin B
XM1 D G S B sky130_fd_pr__nfet_01v8 L=0.94 W=3.2 nf=2 ad='int((nf+1)/2) * W/nf * 0.29' as='int((nf+2)/2) * W/nf * 0.29' pd='2*int((nf+1)/2) * (W/nf + 0.29)'
+ ps='2*int((nf+2)/2) * (W/nf + 0.29)' nrd='0.29 / W' nrs='0.29 / W' sa=0 sb=0 sd=0 mult=1 m=1
.ends

* expanding   symbol:  LELO_ATR_SKY130A/LELOATR_LVT_NCH_4C5F0.sym # of pins=4
** sym_path: /Users/wulff/data/2023/aicex/ip/lelo_temp_sky130a/design/LELO_ATR_SKY130A/LELOATR_LVT_NCH_4C5F0.sym
** sch_path: /Users/wulff/data/2023/aicex/ip/lelo_temp_sky130a/design/LELO_ATR_SKY130A/LELOATR_LVT_NCH_4C5F0.sch
.subckt LELOATR_LVT_NCH_4C5F0 D G S B
*.iopin D
*.iopin G
*.iopin S
*.iopin B
XM1 D G S B sky130_fd_pr__nfet_01v8_lvt L=0.94 W=3.2 nf=2 ad='int((nf+1)/2) * W/nf * 0.29' as='int((nf+2)/2) * W/nf * 0.29' pd='2*int((nf+1)/2) * (W/nf + 0.29)'
+ ps='2*int((nf+2)/2) * (W/nf + 0.29)' nrd='0.29 / W' nrs='0.29 / W' sa=0 sb=0 sd=0 mult=1 m=1
.ends

* expanding   symbol:  JNW_ATR_SKY130A/JNWATR_PCH_4C5F0.sym # of pins=4
** sym_path: /Users/wulff/data/2023/aicex/ip/lelo_temp_sky130a/design/JNW_ATR_SKY130A/JNWATR_PCH_4C5F0.sym
** sch_path: /Users/wulff/data/2023/aicex/ip/lelo_temp_sky130a/design/JNW_ATR_SKY130A/JNWATR_PCH_4C5F0.sch
.subckt JNWATR_PCH_4C5F0 D G S B
*.iopin D
*.iopin G
*.iopin S
*.iopin B
XM1 D G S B sky130_fd_pr__pfet_01v8 L=0.94 W=3.2 nf=2 ad='int((nf+1)/2) * W/nf * 0.29' as='int((nf+2)/2) * W/nf * 0.29' pd='2*int((nf+1)/2) * (W/nf + 0.29)'
+ ps='2*int((nf+2)/2) * (W/nf + 0.29)' nrd='0.29 / W' nrs='0.29 / W' sa=0 sb=0 sd=0 mult=1 m=1
.ends

* expanding   symbol:  JNW_ATR_SKY130A/JNWATR_PCH_4C1F2.sym # of pins=4
** sym_path: /Users/wulff/data/2023/aicex/ip/lelo_temp_sky130a/design/JNW_ATR_SKY130A/JNWATR_PCH_4C1F2.sym
** sch_path: /Users/wulff/data/2023/aicex/ip/lelo_temp_sky130a/design/JNW_ATR_SKY130A/JNWATR_PCH_4C1F2.sch
.subckt JNWATR_PCH_4C1F2 D G S B
*.iopin D
*.iopin G
*.iopin S
*.iopin B
XM1 D G S B sky130_fd_pr__pfet_01v8 L=0.22 W=3.2 nf=2 ad='int((nf+1)/2) * W/nf * 0.29' as='int((nf+2)/2) * W/nf * 0.29' pd='2*int((nf+1)/2) * (W/nf + 0.29)'
+ ps='2*int((nf+2)/2) * (W/nf + 0.29)' nrd='0.29 / W' nrs='0.29 / W' sa=0 sb=0 sd=0 mult=1 m=1
.ends

* expanding   symbol:  JNW_ATR_SKY130A/JNWATR_NCH_4C1F2.sym # of pins=4
** sym_path: /Users/wulff/data/2023/aicex/ip/lelo_temp_sky130a/design/JNW_ATR_SKY130A/JNWATR_NCH_4C1F2.sym
** sch_path: /Users/wulff/data/2023/aicex/ip/lelo_temp_sky130a/design/JNW_ATR_SKY130A/JNWATR_NCH_4C1F2.sch
.subckt JNWATR_NCH_4C1F2 D G S B
*.iopin D
*.iopin G
*.iopin S
*.iopin B
XM1 D G S B sky130_fd_pr__nfet_01v8 L=0.22 W=3.2 nf=2 ad='int((nf+1)/2) * W/nf * 0.29' as='int((nf+2)/2) * W/nf * 0.29' pd='2*int((nf+1)/2) * (W/nf + 0.29)'
+ ps='2*int((nf+2)/2) * (W/nf + 0.29)' nrd='0.29 / W' nrs='0.29 / W' sa=0 sb=0 sd=0 mult=1 m=1
.ends

* expanding   symbol:  JNW_TR_SKY130A/JNWTR_RPPO4.sym # of pins=3
** sym_path: /Users/wulff/data/2023/aicex/ip/lelo_temp_sky130a/design/JNW_TR_SKY130A/JNWTR_RPPO4.sym
** sch_path: /Users/wulff/data/2023/aicex/ip/lelo_temp_sky130a/design/JNW_TR_SKY130A/JNWTR_RPPO4.sch
.subckt JNWTR_RPPO4 N P B
*.iopin P
*.iopin N
*.iopin B
XXA1 N P B JNWTR_RES4
.ends

* expanding   symbol:  JNW_TR_SKY130A/JNWTR_RES4.sym # of pins=3
** sym_path: /Users/wulff/data/2023/aicex/ip/lelo_temp_sky130a/design/JNW_TR_SKY130A/JNWTR_RES4.sym
** sch_path: /Users/wulff/data/2023/aicex/ip/lelo_temp_sky130a/design/JNW_TR_SKY130A/JNWTR_RES4.sch
.subckt JNWTR_RES4 N P B
*.iopin N
*.iopin P
*.iopin B
XR1_0 INT_0 N B sky130_fd_pr__res_high_po W=0.36 L=7.36 mult=1 m=1
XR1_1 INT_1 INT_0 B sky130_fd_pr__res_high_po W=0.36 L=7.36 mult=1 m=1
XR1_2 INT_2 INT_1 B sky130_fd_pr__res_high_po W=0.36 L=7.36 mult=1 m=1
XR1_3 P INT_2 B sky130_fd_pr__res_high_po W=0.36 L=7.36 mult=1 m=1
.ends

.end
