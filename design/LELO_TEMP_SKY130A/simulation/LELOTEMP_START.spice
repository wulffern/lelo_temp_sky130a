** sch_path: /Users/wulff/data/2023/aicex/ip/lelo_temp_sky130a/design/LELO_TEMP_SKY130A/LELOTEMP_START.sch
**.subckt LELOTEMP_START VDD_1V8 VO VCP PWRUP_1V8 PWRUP_N_1V8 VSS
*.ipin VDD_1V8
*.ipin VSS
*.ipin PWRUP_N_1V8
*.ipin PWRUP_1V8
*.opin VO
*.opin VCP
xca9<1> VSTART1 net2 VSS net1 JNWATR_NCH_4C5F0
xca9<0> VSTART1 net2 VSS net1 JNWATR_NCH_4C5F0
xca10 VSTART2 VSTART1 net1 net1 JNWATR_NCH_4C5F0
xba3 VSTART2 VSTART1 VDD_1V8 VDD_1V8 JNWATR_PCH_4C1F2
xca11 VSTART3 VSTART2 net1 net1 JNWATR_NCH_4C1F2
xba4 VSTART3 VSTART2 VDD_1V8 VDD_1V8 JNWATR_PCH_4C5F0
xca13 net4 VSTART3 net1 net1 JNWATR_NCH_4C5F0
xba14 net2 VO VDD_1V8 VDD_1V8 JNWATR_PCH_4C5F0
xca12 net2 net2 VSS VSS JNWATR_NCH_4C5F0
xca14 net3 VSTART3 net1 net1 JNWATR_NCH_4C5F0
xca15 net2 PWRUP_N_1V8 net1 VSS JNWATR_NCH_4C5F0
xba12 TOP PWRUP_N_1V8 VDD_1V8 VDD_1V8 JNWATR_PCH_4C1F2
xca16 VSTART1 PWRUP_N_1V8 net1 net1 JNWATR_NCH_4C5F0
xca17 VCP VCP net3 net1 JNWATR_NCH_4C5F0
xca18 VO VO net4 net1 JNWATR_NCH_4C5F0
xbig<19> SER<18> VSS TOP VDD_1V8 JNWATR_PCH_2C5F0
xbig<18> SER<17> VSS SER<18> VDD_1V8 JNWATR_PCH_2C5F0
xbig<17> SER<16> VSS SER<17> VDD_1V8 JNWATR_PCH_2C5F0
xbig<16> SER<15> VSS SER<16> VDD_1V8 JNWATR_PCH_2C5F0
xbig<15> SER<14> VSS SER<15> VDD_1V8 JNWATR_PCH_2C5F0
xbig<14> SER<13> VSS SER<14> VDD_1V8 JNWATR_PCH_2C5F0
xbig<13> SER<12> VSS SER<13> VDD_1V8 JNWATR_PCH_2C5F0
xbig<12> SER<11> VSS SER<12> VDD_1V8 JNWATR_PCH_2C5F0
xbig<11> SER<10> VSS SER<11> VDD_1V8 JNWATR_PCH_2C5F0
xbig<10> SER<9> VSS SER<10> VDD_1V8 JNWATR_PCH_2C5F0
xbig<9> SER<8> VSS SER<9> VDD_1V8 JNWATR_PCH_2C5F0
xbig<8> SER<7> VSS SER<8> VDD_1V8 JNWATR_PCH_2C5F0
xbig<7> SER<6> VSS SER<7> VDD_1V8 JNWATR_PCH_2C5F0
xbig<6> SER<5> VSS SER<6> VDD_1V8 JNWATR_PCH_2C5F0
xbig<5> SER<4> VSS SER<5> VDD_1V8 JNWATR_PCH_2C5F0
xbig<4> SER<3> VSS SER<4> VDD_1V8 JNWATR_PCH_2C5F0
xbig<3> SER<2> VSS SER<3> VDD_1V8 JNWATR_PCH_2C5F0
xbig<2> SER<1> VSS SER<2> VDD_1V8 JNWATR_PCH_2C5F0
xbig<1> SER<0> VSS SER<1> VDD_1V8 JNWATR_PCH_2C5F0
xbig<0> VSTART1 VSS SER<0> VDD_1V8 JNWATR_PCH_2C5F0
**.ends

* expanding   symbol:  JNW_ATR_SKY130A/JNWATR_NCH_4C5F0.sym # of pins=4
** sym_path: /Users/wulff/data/2023/aicex/ip/lelo_temp_sky130a/design/JNW_ATR_SKY130A/JNWATR_NCH_4C5F0.sym
** sch_path: /Users/wulff/data/2023/aicex/ip/lelo_temp_sky130a/design/JNW_ATR_SKY130A/JNWATR_NCH_4C5F0.sch
.subckt JNWATR_NCH_4C5F0 D G S B
*.iopin D
*.iopin G
*.iopin S
*.iopin B
XM1 D G S B sky130_fd_pr__nfet_01v8 L=0.94 W=3.2 nf=2 ad='int((nf+1)/2) * W/nf * 0.29' as='int((nf+2)/2) * W/nf * 0.29' pd='2*int((nf+1)/2) * (W/nf + 0.29)'
+ ps='2*int((nf+2)/2) * (W/nf + 0.29)' nrd='0.29 / W' nrs='0.29 / W' sa=0 sb=0 sd=0 mult=1 m=1
.ends

* expanding   symbol:  JNW_ATR_SKY130A/JNWATR_PCH_4C1F2.sym # of pins=4
** sym_path: /Users/wulff/data/2023/aicex/ip/lelo_temp_sky130a/design/JNW_ATR_SKY130A/JNWATR_PCH_4C1F2.sym
** sch_path: /Users/wulff/data/2023/aicex/ip/lelo_temp_sky130a/design/JNW_ATR_SKY130A/JNWATR_PCH_4C1F2.sch
.subckt JNWATR_PCH_4C1F2 D G S B
*.iopin D
*.iopin G
*.iopin S
*.iopin B
XM1 D G S B sky130_fd_pr__pfet_01v8 L=0.22 W=3.2 nf=2 ad='int((nf+1)/2) * W/nf * 0.29' as='int((nf+2)/2) * W/nf * 0.29' pd='2*int((nf+1)/2) * (W/nf + 0.29)'
+ ps='2*int((nf+2)/2) * (W/nf + 0.29)' nrd='0.29 / W' nrs='0.29 / W' sa=0 sb=0 sd=0 mult=1 m=1
.ends

* expanding   symbol:  JNW_ATR_SKY130A/JNWATR_NCH_4C1F2.sym # of pins=4
** sym_path: /Users/wulff/data/2023/aicex/ip/lelo_temp_sky130a/design/JNW_ATR_SKY130A/JNWATR_NCH_4C1F2.sym
** sch_path: /Users/wulff/data/2023/aicex/ip/lelo_temp_sky130a/design/JNW_ATR_SKY130A/JNWATR_NCH_4C1F2.sch
.subckt JNWATR_NCH_4C1F2 D G S B
*.iopin D
*.iopin G
*.iopin S
*.iopin B
XM1 D G S B sky130_fd_pr__nfet_01v8 L=0.22 W=3.2 nf=2 ad='int((nf+1)/2) * W/nf * 0.29' as='int((nf+2)/2) * W/nf * 0.29' pd='2*int((nf+1)/2) * (W/nf + 0.29)'
+ ps='2*int((nf+2)/2) * (W/nf + 0.29)' nrd='0.29 / W' nrs='0.29 / W' sa=0 sb=0 sd=0 mult=1 m=1
.ends

* expanding   symbol:  JNW_ATR_SKY130A/JNWATR_PCH_4C5F0.sym # of pins=4
** sym_path: /Users/wulff/data/2023/aicex/ip/lelo_temp_sky130a/design/JNW_ATR_SKY130A/JNWATR_PCH_4C5F0.sym
** sch_path: /Users/wulff/data/2023/aicex/ip/lelo_temp_sky130a/design/JNW_ATR_SKY130A/JNWATR_PCH_4C5F0.sch
.subckt JNWATR_PCH_4C5F0 D G S B
*.iopin D
*.iopin G
*.iopin S
*.iopin B
XM1 D G S B sky130_fd_pr__pfet_01v8 L=0.94 W=3.2 nf=2 ad='int((nf+1)/2) * W/nf * 0.29' as='int((nf+2)/2) * W/nf * 0.29' pd='2*int((nf+1)/2) * (W/nf + 0.29)'
+ ps='2*int((nf+2)/2) * (W/nf + 0.29)' nrd='0.29 / W' nrs='0.29 / W' sa=0 sb=0 sd=0 mult=1 m=1
.ends

* expanding   symbol:  JNW_ATR_SKY130A/JNWATR_PCH_2C5F0.sym # of pins=4
** sym_path: /Users/wulff/data/2023/aicex/ip/lelo_temp_sky130a/design/JNW_ATR_SKY130A/JNWATR_PCH_2C5F0.sym
** sch_path: /Users/wulff/data/2023/aicex/ip/lelo_temp_sky130a/design/JNW_ATR_SKY130A/JNWATR_PCH_2C5F0.sch
.subckt JNWATR_PCH_2C5F0 D G S B
*.iopin D
*.iopin G
*.iopin S
*.iopin B
XM1 D G S B sky130_fd_pr__pfet_01v8 L=0.94 W=1.92 nf=2 ad='int((nf+1)/2) * W/nf * 0.29' as='int((nf+2)/2) * W/nf * 0.29' pd='2*int((nf+1)/2) * (W/nf + 0.29)'
+ ps='2*int((nf+2)/2) * (W/nf + 0.29)' nrd='0.29 / W' nrs='0.29 / W' sa=0 sb=0 sd=0 mult=1 m=1
.ends

.end
