** sch_path: /Users/wulff/data/2023/aicex/ip/lelo_temp_sky130a/design/LELO_TEMP_SKY130A/LELO_TEMP.sch
**.subckt LELO_TEMP VDD_1V8 OSC_TEMP_1V8 PWRUP_1V8 VSS
*.ipin VDD_1V8
*.ipin VSS
*.ipin PWRUP_1V8
*.opin OSC_TEMP_1V8
x1_ibp VDD_1V8 LPI IBP_1U<3> IBP_1U<2> IBP_1U<1> IBP_1U<0> LPI VC PWRUP_B_1V8 VSS PWRUP_N_1V8 LELOTEMP_BIAS_IBP
xd1<9> VSS IBP_1U<0> JNWTR_CAPX1
xd1<8> VSS IBP_1U<0> JNWTR_CAPX1
xd1<7> VSS IBP_1U<0> JNWTR_CAPX1
xd1<6> VSS IBP_1U<0> JNWTR_CAPX1
xd1<5> VSS IBP_1U<0> JNWTR_CAPX1
xd1<4> VSS IBP_1U<0> JNWTR_CAPX1
xd1<3> VSS IBP_1U<0> JNWTR_CAPX1
xd1<2> VSS IBP_1U<0> JNWTR_CAPX1
xd1<1> VSS IBP_1U<0> JNWTR_CAPX1
xd1<0> VSS IBP_1U<0> JNWTR_CAPX1
xg3<1> IBP_1U<0> RST VSS VSS JNWATR_NCH_4C1F2
xg3<0> IBP_1U<0> RST VSS VSS JNWATR_NCH_4C1F2
x7 CMPO net1 VDD_1V8 VSS JNWTR_IVX1_CV
x8 net1 CLK VDD_1V8 VSS JNWTR_IVX1_CV
x10 OSC_TEMP_1V8 net2 VDD_1V8 VSS JNWTR_IVX1_CV
x9 net2 CLK VDD_1V8 OSC_TEMP_1V8 net6 VDD_1V8 VSS JNWTR_DFRNQNX1_CV
x6 PWRUP_1V8 PWRUP_N_1V8 VDD_1V8 VSS JNWTR_IVX1_CV
x2 PWRUP_N_1V8 PWRUP_B_1V8 VDD_1V8 VSS JNWTR_IVX1_CV
x1_cmp VDD_1V8 IBP_1U<0> CMPO VC VSS PWRUP_B_1V8 PWRUP_N_1V8 IBP_1U<3> IBP_1U<2> IBP_1U<1> LELOTEMP_CMP
x1 CLK net3 VDD_1V8 VSS JNWTR_IVX1_CV
x3 net3 net5 VDD_1V8 VSS JNWTR_IVX1_CV
x4 net5 net4 VDD_1V8 VSS JNWTR_IVX1_CV
x5 net4 RST VDD_1V8 VSS JNWTR_IVX1_CV
**.ends

* expanding   symbol:  LELO_TEMP_SKY130A/LELOTEMP_BIAS_IBP.sym # of pins=8
** sym_path: /Users/wulff/data/2023/aicex/ip/lelo_temp_sky130a/design/LELO_TEMP_SKY130A/LELOTEMP_BIAS_IBP.sym
** sch_path: /Users/wulff/data/2023/aicex/ip/lelo_temp_sky130a/design/LELO_TEMP_SKY130A/LELOTEMP_BIAS_IBP.sch
.subckt LELOTEMP_BIAS_IBP VDD_1V8 LPI IBP_1U<3> IBP_1U<2> IBP_1U<1> IBP_1U<0> LPO VD1 PWRUP_1V8 VSS PWRUP_N_1V8
*.ipin VDD_1V8
*.ipin VSS
*.ipin LPI
*.opin LPO
*.opin IBP_1U<3>,IBP_1U<2>,IBP_1U<1>,IBP_1U<0>
*.opin VD1
*.ipin PWRUP_1V8
*.ipin PWRUP_N_1V8
xca2 VBD2 LPI VDD_1V8 VDD_1V8 JNWATR_PCH_4C5F0
xca1<7> VBD1 LPI VDD_1V8 VDD_1V8 JNWATR_PCH_4C5F0
xca1<6> VBD1 LPI VDD_1V8 VDD_1V8 JNWATR_PCH_4C5F0
xca1<5> VBD1 LPI VDD_1V8 VDD_1V8 JNWATR_PCH_4C5F0
xca1<4> VBD1 LPI VDD_1V8 VDD_1V8 JNWATR_PCH_4C5F0
xca1<3> VBD1 LPI VDD_1V8 VDD_1V8 JNWATR_PCH_4C5F0
xca1<2> VBD1 LPI VDD_1V8 VDD_1V8 JNWATR_PCH_4C5F0
xca1<1> VBD1 LPI VDD_1V8 VDD_1V8 JNWATR_PCH_4C5F0
xca1<0> VBD1 LPI VDD_1V8 VDD_1V8 JNWATR_PCH_4C5F0
xd1<9> LPI VDD_1V8 JNWTR_CAPX1
xd1<8> LPI VDD_1V8 JNWTR_CAPX1
xd1<7> LPI VDD_1V8 JNWTR_CAPX1
xd1<6> LPI VDD_1V8 JNWTR_CAPX1
xd1<5> LPI VDD_1V8 JNWTR_CAPX1
xd1<4> LPI VDD_1V8 JNWTR_CAPX1
xd1<3> LPI VDD_1V8 JNWTR_CAPX1
xd1<2> LPI VDD_1V8 JNWTR_CAPX1
xd1<1> LPI VDD_1V8 JNWTR_CAPX1
xd1<0> LPI VDD_1V8 JNWTR_CAPX1
xad6 VDD_1V8 VR1 LPO VD1 VSS PWRUP_1V8 PWRUP_N_1V8 VCP LELOTEMP_OTA
xca3<3> IBD<3> LPI VDD_1V8 VDD_1V8 JNWATR_PCH_4C5F0
xca3<2> IBD<2> LPI VDD_1V8 VDD_1V8 JNWATR_PCH_4C5F0
xca3<1> IBD<1> LPI VDD_1V8 VDD_1V8 JNWATR_PCH_4C5F0
xca3<0> IBD<0> LPI VDD_1V8 VDD_1V8 JNWATR_PCH_4C5F0
xac2 VD2 net1 VSS JNWTR_RPPO4
xg3 LPI PWRUP_1V8 VS2 VSS JNWATR_NCH_4C5F0
xe1 VD2 VD1 VSS JNWBIAS_BIPOLAR
xg1 VR1 VR1 VD2 VSS JNWATR_NCH_4C5F0
xg2 VS2 VS2 VS1 VSS JNWATR_NCH_4C5F0
xac3 net1 VR1 VSS JNWTR_RPPO8
xcc<4> VDD_1V8 VDD_1V8 VDD_1V8 VDD_1V8 JNWATR_PCH_4C5F0
xcc<3> VDD_1V8 VDD_1V8 VDD_1V8 VDD_1V8 JNWATR_PCH_4C5F0
xcc<2> VDD_1V8 VDD_1V8 VDD_1V8 VDD_1V8 JNWATR_PCH_4C5F0
xcc<1> VDD_1V8 VDD_1V8 VDD_1V8 VDD_1V8 JNWATR_PCH_4C5F0
xcc<0> VDD_1V8 VDD_1V8 VDD_1V8 VDD_1V8 JNWATR_PCH_4C5F0
xc1 VSS VR1 VS1 VDD_1V8 JNWATR_PCH_4C5F0
xca2<3> IBP_1U<3> VCP IBD<3> VDD_1V8 JNWATR_PCH_4C1F2
xca2<2> IBP_1U<2> VCP IBD<2> VDD_1V8 JNWATR_PCH_4C1F2
xca2<1> IBP_1U<1> VCP IBD<1> VDD_1V8 JNWATR_PCH_4C1F2
xca2<0> IBP_1U<0> VCP IBD<0> VDD_1V8 JNWATR_PCH_4C1F2
xca4 VR1 VCP VBD2 VDD_1V8 JNWATR_PCH_4C1F2
xca5<7> VD1 VCP VBD1 VDD_1V8 JNWATR_PCH_4C1F2
xca5<6> VD1 VCP VBD1 VDD_1V8 JNWATR_PCH_4C1F2
xca5<5> VD1 VCP VBD1 VDD_1V8 JNWATR_PCH_4C1F2
xca5<4> VD1 VCP VBD1 VDD_1V8 JNWATR_PCH_4C1F2
xca5<3> VD1 VCP VBD1 VDD_1V8 JNWATR_PCH_4C1F2
xca5<2> VD1 VCP VBD1 VDD_1V8 JNWATR_PCH_4C1F2
xca5<1> VD1 VCP VBD1 VDD_1V8 JNWATR_PCH_4C1F2
xca5<0> VD1 VCP VBD1 VDD_1V8 JNWATR_PCH_4C1F2
.ends

* expanding   symbol:  JNW_TR_SKY130A/JNWTR_CAPX1.sym # of pins=2
** sym_path: /Users/wulff/data/2023/aicex/ip/lelo_temp_sky130a/design/JNW_TR_SKY130A/JNWTR_CAPX1.sym
** sch_path: /Users/wulff/data/2023/aicex/ip/lelo_temp_sky130a/design/JNW_TR_SKY130A/JNWTR_CAPX1.sch
.subckt JNWTR_CAPX1 A B
*.iopin A
*.iopin B
XC1 B A sky130_fd_pr__cap_mim_m3_1 W=5 L=5 MF=1 m=1
.ends

* expanding   symbol:  JNW_ATR_SKY130A/JNWATR_NCH_4C1F2.sym # of pins=4
** sym_path: /Users/wulff/data/2023/aicex/ip/lelo_temp_sky130a/design/JNW_ATR_SKY130A/JNWATR_NCH_4C1F2.sym
** sch_path: /Users/wulff/data/2023/aicex/ip/lelo_temp_sky130a/design/JNW_ATR_SKY130A/JNWATR_NCH_4C1F2.sch
.subckt JNWATR_NCH_4C1F2 D G S B
*.iopin D
*.iopin G
*.iopin S
*.iopin B
XM1 D G S B sky130_fd_pr__nfet_01v8 L=0.22 W=3.2 nf=2 ad='int((nf+1)/2) * W/nf * 0.29' as='int((nf+2)/2) * W/nf * 0.29' pd='2*int((nf+1)/2) * (W/nf + 0.29)'
+ ps='2*int((nf+2)/2) * (W/nf + 0.29)' nrd='0.29 / W' nrs='0.29 / W' sa=0 sb=0 sd=0 mult=1 m=1
.ends

* expanding   symbol:  JNW_TR_SKY130A/JNWTR_IVX1_CV.sym # of pins=4
** sym_path: /Users/wulff/data/2023/aicex/ip/lelo_temp_sky130a/design/JNW_TR_SKY130A/JNWTR_IVX1_CV.sym
** sch_path: /Users/wulff/data/2023/aicex/ip/lelo_temp_sky130a/design/JNW_TR_SKY130A/JNWTR_IVX1_CV.sch
.subckt JNWTR_IVX1_CV A Y AVDD AVSS
*.ipin A
*.opin Y
*.ipin AVDD
*.ipin AVSS
XMN0 Y A AVSS AVSS JNWTR_NCHDL
XMP0 Y A AVDD AVDD JNWTR_PCHDL
.ends

* expanding   symbol:  JNW_TR_SKY130A/JNWTR_DFRNQNX1_CV.sym # of pins=7
** sym_path: /Users/wulff/data/2023/aicex/ip/lelo_temp_sky130a/design/JNW_TR_SKY130A/JNWTR_DFRNQNX1_CV.sym
** sch_path: /Users/wulff/data/2023/aicex/ip/lelo_temp_sky130a/design/JNW_TR_SKY130A/JNWTR_DFRNQNX1_CV.sch
.subckt JNWTR_DFRNQNX1_CV D CK RN Q QN AVDD AVSS
*.iopin D
*.iopin CK
*.iopin RN
*.iopin Q
*.iopin QN
*.iopin AVDD
*.iopin AVSS
XXA0 AVDD AVSS JNWTR_TAPCELLB_CV
XXA1 CK RN CKN AVDD AVSS JNWTR_NDX1_CV
XXA2 CKN CKB AVDD AVSS JNWTR_IVX1_CV
XXA3 D CKN CKB A0 AVDD AVSS JNWTR_IVTRIX1_CV
XXA4 A1 CKB CKN A0 AVDD AVSS JNWTR_IVTRIX1_CV
XXA5 A0 A1 AVDD AVSS JNWTR_IVX1_CV
XXA6 A1 CKB CKN QN AVDD AVSS JNWTR_IVTRIX1_CV
XXA7 Q CKN CKB RN QN AVDD AVSS JNWTR_NDTRIX1_CV
XXA8 QN Q AVDD AVSS JNWTR_IVX1_CV
.ends

* expanding   symbol:  LELO_TEMP_SKY130A/LELOTEMP_CMP.sym # of pins=8
** sym_path: /Users/wulff/data/2023/aicex/ip/lelo_temp_sky130a/design/LELO_TEMP_SKY130A/LELOTEMP_CMP.sym
** sch_path: /Users/wulff/data/2023/aicex/ip/lelo_temp_sky130a/design/LELO_TEMP_SKY130A/LELOTEMP_CMP.sch
.subckt LELOTEMP_CMP VDD_1V8 VIP VO VIN VSS PWRUP_1V8 PWRUP_N_1V8 IBP_1U<2> IBP_1U<1> IBP_1U<0>
*.opin VO
*.ipin VIP
*.ipin VIN
*.ipin VDD_1V8
*.ipin VSS
*.ipin PWRUP_N_1V8
*.ipin PWRUP_1V8
*.ipin IBP_1U<2>,IBP_1U<1>,IBP_1U<0>
xba1<7> VD1 VIN IBP_1U<2> VDD_1V8 JNWATR_PCH_12C1F2
xba1<6> VD1 VIN IBP_1U<1> VDD_1V8 JNWATR_PCH_12C1F2
xba1<5> VD1 VIN IBP_1U<0> VDD_1V8 JNWATR_PCH_12C1F2
xba1<4> VD1 VIN IBP_1U<2> VDD_1V8 JNWATR_PCH_12C1F2
xba1<3> VD1 VIN IBP_1U<1> VDD_1V8 JNWATR_PCH_12C1F2
xba1<2> VD1 VIN IBP_1U<0> VDD_1V8 JNWATR_PCH_12C1F2
xba1<1> VD1 VIN IBP_1U<2> VDD_1V8 JNWATR_PCH_12C1F2
xba1<0> VD1 VIN IBP_1U<1> VDD_1V8 JNWATR_PCH_12C1F2
xbb2<7> VD2 VIP IBP_1U<2> VDD_1V8 JNWATR_PCH_12C1F2
xbb2<6> VD2 VIP IBP_1U<1> VDD_1V8 JNWATR_PCH_12C1F2
xbb2<5> VD2 VIP IBP_1U<0> VDD_1V8 JNWATR_PCH_12C1F2
xbb2<4> VD2 VIP IBP_1U<2> VDD_1V8 JNWATR_PCH_12C1F2
xbb2<3> VD2 VIP IBP_1U<1> VDD_1V8 JNWATR_PCH_12C1F2
xbb2<2> VD2 VIP IBP_1U<0> VDD_1V8 JNWATR_PCH_12C1F2
xbb2<1> VD2 VIP IBP_1U<2> VDD_1V8 JNWATR_PCH_12C1F2
xbb2<0> VD2 VIP IBP_1U<1> VDD_1V8 JNWATR_PCH_12C1F2
xca4 VD1 VD1 VSS VSS JNWATR_NCH_4C5F0
xcb2 VD2 VD2 VSS VSS JNWATR_NCH_4C5F0
xba6 net1 net1 VDD_1V8 VDD_1V8 JNWATR_PCH_4C5F0
xca3 net1 VD1 VSS VSS JNWATR_NCH_4C5F0
xbb3 VO net1 VDD_1V8 VDD_1V8 JNWATR_PCH_4C5F0
xcb4 VO VD2 VSS VSS JNWATR_NCH_4C5F0
xba7 net1 PWRUP_1V8 VDD_1V8 VDD_1V8 JNWATR_PCH_4C5F0
xba2 VO PWRUP_1V8 VDD_1V8 VDD_1V8 JNWATR_PCH_4C5F0
xca1 VD1 PWRUP_N_1V8 VSS VSS JNWATR_NCH_4C5F0
xca2 VD2 PWRUP_N_1V8 VSS VSS JNWATR_NCH_4C5F0
.ends

* expanding   symbol:  JNW_ATR_SKY130A/JNWATR_PCH_4C5F0.sym # of pins=4
** sym_path: /Users/wulff/data/2023/aicex/ip/lelo_temp_sky130a/design/JNW_ATR_SKY130A/JNWATR_PCH_4C5F0.sym
** sch_path: /Users/wulff/data/2023/aicex/ip/lelo_temp_sky130a/design/JNW_ATR_SKY130A/JNWATR_PCH_4C5F0.sch
.subckt JNWATR_PCH_4C5F0 D G S B
*.iopin D
*.iopin G
*.iopin S
*.iopin B
XM1 D G S B sky130_fd_pr__pfet_01v8 L=0.94 W=3.2 nf=2 ad='int((nf+1)/2) * W/nf * 0.29' as='int((nf+2)/2) * W/nf * 0.29' pd='2*int((nf+1)/2) * (W/nf + 0.29)'
+ ps='2*int((nf+2)/2) * (W/nf + 0.29)' nrd='0.29 / W' nrs='0.29 / W' sa=0 sb=0 sd=0 mult=1 m=1
.ends

* expanding   symbol:  LELO_TEMP_SKY130A/LELOTEMP_OTA.sym # of pins=8
** sym_path: /Users/wulff/data/2023/aicex/ip/lelo_temp_sky130a/design/LELO_TEMP_SKY130A/LELOTEMP_OTA.sym
** sch_path: /Users/wulff/data/2023/aicex/ip/lelo_temp_sky130a/design/LELO_TEMP_SKY130A/LELOTEMP_OTA.sch
.subckt LELOTEMP_OTA VDD_1V8 VIP VO VIN VSS PWRUP_1V8 PWRUP_N_1V8 VCP
*.opin VO
*.ipin VIP
*.ipin VIN
*.ipin VDD_1V8
*.ipin VSS
*.ipin PWRUP_N_1V8
*.ipin PWRUP_1V8
*.opin VCP
xba1<7> VD1 VIN VS VDD_1V8 JNWATR_PCH_12C1F2
xba1<6> VD1 VIN VS VDD_1V8 JNWATR_PCH_12C1F2
xba1<5> VD1 VIN VS VDD_1V8 JNWATR_PCH_12C1F2
xba1<4> VD1 VIN VS VDD_1V8 JNWATR_PCH_12C1F2
xba1<3> VD1 VIN VS VDD_1V8 JNWATR_PCH_12C1F2
xba1<2> VD1 VIN VS VDD_1V8 JNWATR_PCH_12C1F2
xba1<1> VD1 VIN VS VDD_1V8 JNWATR_PCH_12C1F2
xba1<0> VD1 VIN VS VDD_1V8 JNWATR_PCH_12C1F2
xbb2<7> VD2 VIP VS VDD_1V8 JNWATR_PCH_12C1F2
xbb2<6> VD2 VIP VS VDD_1V8 JNWATR_PCH_12C1F2
xbb2<5> VD2 VIP VS VDD_1V8 JNWATR_PCH_12C1F2
xbb2<4> VD2 VIP VS VDD_1V8 JNWATR_PCH_12C1F2
xbb2<3> VD2 VIP VS VDD_1V8 JNWATR_PCH_12C1F2
xbb2<2> VD2 VIP VS VDD_1V8 JNWATR_PCH_12C1F2
xbb2<1> VD2 VIP VS VDD_1V8 JNWATR_PCH_12C1F2
xbb2<0> VD2 VIP VS VDD_1V8 JNWATR_PCH_12C1F2
xca1<3> VD1 VD1 VSS VSS JNWATR_NCH_4C5F0
xca1<2> VD1 VD1 VSS VSS JNWATR_NCH_4C5F0
xca1<1> VD1 VD1 VSS VSS JNWATR_NCH_4C5F0
xca1<0> VD1 VD1 VSS VSS JNWATR_NCH_4C5F0
xcb2<3> VD2 VD2 VSS VSS JNWATR_NCH_4C5F0
xcb2<2> VD2 VD2 VSS VSS JNWATR_NCH_4C5F0
xcb2<1> VD2 VD2 VSS VSS JNWATR_NCH_4C5F0
xcb2<0> VD2 VD2 VSS VSS JNWATR_NCH_4C5F0
xba6 net1 net1 VDD_1V8 VDD_1V8 JNWATR_PCH_12C5F0
xca3 net1 VD1 VSS VSS JNWATR_NCH_4C5F0
xbb3 VO net1 VDD_1V8 VDD_1V8 JNWATR_PCH_12C5F0
xcb4 VO VD2 VSS VSS JNWATR_NCH_4C5F0
xd2 net2 VS VSS JNWTR_RPPO2
xba7 net1 PWRUP_1V8 VDD_1V8 VDD_1V8 JNWATR_PCH_12C5F0
xba1 net2 PWRUP_N_1V8 VDD_1V8 VDD_1V8 JNWATR_PCH_12C5F0
xba2 VO PWRUP_1V8 VDD_1V8 VDD_1V8 JNWATR_PCH_12C5F0
xca1 VD1 PWRUP_N_1V8 VSS VSS JNWATR_NCH_4C5F0
xca2 VD2 PWRUP_N_1V8 VSS VSS JNWATR_NCH_4C5F0
xba4 net3 VIN VS VDD_1V8 JNWATR_PCH_12C1F2
xbb5 net3 VIP VS VDD_1V8 JNWATR_PCH_12C1F2
xcb1 net3 net3 VSS VSS JNWATR_NCH_4C5F0
xcb2 VCP net3 VSS VSS JNWATR_NCH_4C5F0
xbb6 net4 VCP VDD_1V8 VDD_1V8 JNWATR_PCH_4C5F0
xbb1 net5 VCP net4 VDD_1V8 JNWATR_PCH_4C5F0
xbb2 net7 VCP net5 VDD_1V8 JNWATR_PCH_4C5F0
xbb4 net6 VCP net7 VDD_1V8 JNWATR_PCH_4C5F0
xbb7 VCP VCP net6 VDD_1V8 JNWATR_PCH_4C5F0
xca4 net3 PWRUP_N_1V8 VSS VSS JNWATR_NCH_4C5F0
xba3 VCP PWRUP_1V8 VDD_1V8 VDD_1V8 JNWATR_PCH_12C5F0
.ends

* expanding   symbol:  JNW_TR_SKY130A/JNWTR_RPPO4.sym # of pins=3
** sym_path: /Users/wulff/data/2023/aicex/ip/lelo_temp_sky130a/design/JNW_TR_SKY130A/JNWTR_RPPO4.sym
** sch_path: /Users/wulff/data/2023/aicex/ip/lelo_temp_sky130a/design/JNW_TR_SKY130A/JNWTR_RPPO4.sch
.subckt JNWTR_RPPO4 N P B
*.iopin P
*.iopin N
*.iopin B
XXA1 N P B JNWTR_RES4
.ends

* expanding   symbol:  JNW_ATR_SKY130A/JNWATR_NCH_4C5F0.sym # of pins=4
** sym_path: /Users/wulff/data/2023/aicex/ip/lelo_temp_sky130a/design/JNW_ATR_SKY130A/JNWATR_NCH_4C5F0.sym
** sch_path: /Users/wulff/data/2023/aicex/ip/lelo_temp_sky130a/design/JNW_ATR_SKY130A/JNWATR_NCH_4C5F0.sch
.subckt JNWATR_NCH_4C5F0 D G S B
*.iopin D
*.iopin G
*.iopin S
*.iopin B
XM1 D G S B sky130_fd_pr__nfet_01v8 L=0.94 W=3.2 nf=2 ad='int((nf+1)/2) * W/nf * 0.29' as='int((nf+2)/2) * W/nf * 0.29' pd='2*int((nf+1)/2) * (W/nf + 0.29)'
+ ps='2*int((nf+2)/2) * (W/nf + 0.29)' nrd='0.29 / W' nrs='0.29 / W' sa=0 sb=0 sd=0 mult=1 m=1
.ends

* expanding   symbol:  JNW_BIAS_SKY130A/JNWBIAS_BIPOLAR.sym # of pins=3
** sym_path: /Users/wulff/data/2023/aicex/ip/lelo_temp_sky130a/design/JNW_BIAS_SKY130A/JNWBIAS_BIPOLAR.sym
** sch_path: /Users/wulff/data/2023/aicex/ip/lelo_temp_sky130a/design/JNW_BIAS_SKY130A/JNWBIAS_BIPOLAR.sch
.subckt JNWBIAS_BIPOLAR VD2 VD1 VSS
*.ipin VSS
*.ipin VD1
*.ipin VD2
XQ1 VSS VSS VD1 sky130_fd_pr__pnp_05v5_W3p40L3p40 m=1 mult=1
XQ2<7> VSS VSS VD2 sky130_fd_pr__pnp_05v5_W3p40L3p40 m=1 mult=1
XQ2<6> VSS VSS VD2 sky130_fd_pr__pnp_05v5_W3p40L3p40 m=1 mult=1
XQ2<5> VSS VSS VD2 sky130_fd_pr__pnp_05v5_W3p40L3p40 m=1 mult=1
XQ2<4> VSS VSS VD2 sky130_fd_pr__pnp_05v5_W3p40L3p40 m=1 mult=1
XQ2<3> VSS VSS VD2 sky130_fd_pr__pnp_05v5_W3p40L3p40 m=1 mult=1
XQ2<2> VSS VSS VD2 sky130_fd_pr__pnp_05v5_W3p40L3p40 m=1 mult=1
XQ2<1> VSS VSS VD2 sky130_fd_pr__pnp_05v5_W3p40L3p40 m=1 mult=1
XQ2<0> VSS VSS VD2 sky130_fd_pr__pnp_05v5_W3p40L3p40 m=1 mult=1
.ends

* expanding   symbol:  JNW_TR_SKY130A/JNWTR_RPPO8.sym # of pins=3
** sym_path: /Users/wulff/data/2023/aicex/ip/lelo_temp_sky130a/design/JNW_TR_SKY130A/JNWTR_RPPO8.sym
** sch_path: /Users/wulff/data/2023/aicex/ip/lelo_temp_sky130a/design/JNW_TR_SKY130A/JNWTR_RPPO8.sch
.subckt JNWTR_RPPO8 N P B
*.iopin P
*.iopin N
*.iopin B
XXA1 N P B JNWTR_RES8
.ends

* expanding   symbol:  JNW_ATR_SKY130A/JNWATR_PCH_4C1F2.sym # of pins=4
** sym_path: /Users/wulff/data/2023/aicex/ip/lelo_temp_sky130a/design/JNW_ATR_SKY130A/JNWATR_PCH_4C1F2.sym
** sch_path: /Users/wulff/data/2023/aicex/ip/lelo_temp_sky130a/design/JNW_ATR_SKY130A/JNWATR_PCH_4C1F2.sch
.subckt JNWATR_PCH_4C1F2 D G S B
*.iopin D
*.iopin G
*.iopin S
*.iopin B
XM1 D G S B sky130_fd_pr__pfet_01v8 L=0.22 W=3.2 nf=2 ad='int((nf+1)/2) * W/nf * 0.29' as='int((nf+2)/2) * W/nf * 0.29' pd='2*int((nf+1)/2) * (W/nf + 0.29)'
+ ps='2*int((nf+2)/2) * (W/nf + 0.29)' nrd='0.29 / W' nrs='0.29 / W' sa=0 sb=0 sd=0 mult=1 m=1
.ends

* expanding   symbol:  JNW_TR_SKY130A/JNWTR_NCHDL.sym # of pins=4
** sym_path: /Users/wulff/data/2023/aicex/ip/lelo_temp_sky130a/design/JNW_TR_SKY130A/JNWTR_NCHDL.sym
** sch_path: /Users/wulff/data/2023/aicex/ip/lelo_temp_sky130a/design/JNW_TR_SKY130A/JNWTR_NCHDL.sch
.subckt JNWTR_NCHDL D G S B
*.iopin D
*.iopin G
*.iopin S
*.iopin B
XM1 D G S B sky130_fd_pr__nfet_01v8 L=0.16 W=0.9 nf=1 ad='int((nf+1)/2) * W/nf * 0.29' as='int((nf+2)/2) * W/nf * 0.29' pd='2*int((nf+1)/2) * (W/nf + 0.29)'
+ ps='2*int((nf+2)/2) * (W/nf + 0.29)' nrd='0.29 / W' nrs='0.29 / W' sa=0 sb=0 sd=0 mult=1 m=1
.ends

* expanding   symbol:  JNW_TR_SKY130A/JNWTR_PCHDL.sym # of pins=4
** sym_path: /Users/wulff/data/2023/aicex/ip/lelo_temp_sky130a/design/JNW_TR_SKY130A/JNWTR_PCHDL.sym
** sch_path: /Users/wulff/data/2023/aicex/ip/lelo_temp_sky130a/design/JNW_TR_SKY130A/JNWTR_PCHDL.sch
.subckt JNWTR_PCHDL D G S B
*.iopin D
*.iopin G
*.iopin S
*.iopin B
XM1 D G S B sky130_fd_pr__pfet_01v8 L=0.16 W=0.9 nf=1 ad='int((nf+1)/2) * W/nf * 0.29' as='int((nf+2)/2) * W/nf * 0.29' pd='2*int((nf+1)/2) * (W/nf + 0.29)'
+ ps='2*int((nf+2)/2) * (W/nf + 0.29)' nrd='0.29 / W' nrs='0.29 / W' sa=0 sb=0 sd=0 mult=1 m=1
.ends

* expanding   symbol:  JNW_TR_SKY130A/JNWTR_TAPCELLB_CV.sym # of pins=2
** sym_path: /Users/wulff/data/2023/aicex/ip/lelo_temp_sky130a/design/JNW_TR_SKY130A/JNWTR_TAPCELLB_CV.sym
** sch_path: /Users/wulff/data/2023/aicex/ip/lelo_temp_sky130a/design/JNW_TR_SKY130A/JNWTR_TAPCELLB_CV.sch
.subckt JNWTR_TAPCELLB_CV AVDD AVSS
*.iopin AVDD
*.iopin AVSS
XMN1 AVSS AVSS AVSS AVSS JNWTR_NCHDL
XMP1 AVDD AVDD AVDD AVDD JNWTR_PCHDL
.ends

* expanding   symbol:  JNW_TR_SKY130A/JNWTR_NDX1_CV.sym # of pins=5
** sym_path: /Users/wulff/data/2023/aicex/ip/lelo_temp_sky130a/design/JNW_TR_SKY130A/JNWTR_NDX1_CV.sym
** sch_path: /Users/wulff/data/2023/aicex/ip/lelo_temp_sky130a/design/JNW_TR_SKY130A/JNWTR_NDX1_CV.sch
.subckt JNWTR_NDX1_CV A B Y AVDD AVSS
*.iopin A
*.iopin B
*.iopin Y
*.iopin AVDD
*.iopin AVSS
XMN0 N1 A AVSS AVSS JNWTR_NCHDL
XMN1 Y B N1 AVSS JNWTR_NCHDL
XMP0 Y A AVDD AVDD JNWTR_PCHDL
XMP1 AVDD B Y AVDD JNWTR_PCHDL
.ends

* expanding   symbol:  JNW_TR_SKY130A/JNWTR_IVTRIX1_CV.sym # of pins=6
** sym_path: /Users/wulff/data/2023/aicex/ip/lelo_temp_sky130a/design/JNW_TR_SKY130A/JNWTR_IVTRIX1_CV.sym
** sch_path: /Users/wulff/data/2023/aicex/ip/lelo_temp_sky130a/design/JNW_TR_SKY130A/JNWTR_IVTRIX1_CV.sch
.subckt JNWTR_IVTRIX1_CV A C CN Y AVDD AVSS
*.iopin A
*.iopin C
*.iopin CN
*.iopin Y
*.iopin AVDD
*.iopin AVSS
XMN0 N1 A AVSS AVSS JNWTR_NCHDL
XMN1 Y C N1 AVSS JNWTR_NCHDL
XMP0 N2 A AVDD AVDD JNWTR_PCHDL
XMP1 Y CN N2 AVDD JNWTR_PCHDL
.ends

* expanding   symbol:  JNW_TR_SKY130A/JNWTR_NDTRIX1_CV.sym # of pins=7
** sym_path: /Users/wulff/data/2023/aicex/ip/lelo_temp_sky130a/design/JNW_TR_SKY130A/JNWTR_NDTRIX1_CV.sym
** sch_path: /Users/wulff/data/2023/aicex/ip/lelo_temp_sky130a/design/JNW_TR_SKY130A/JNWTR_NDTRIX1_CV.sch
.subckt JNWTR_NDTRIX1_CV A C CN RN Y AVDD AVSS
*.iopin A
*.iopin C
*.iopin CN
*.iopin RN
*.iopin Y
*.iopin AVDD
*.iopin AVSS
XMN2 N1 RN AVSS AVSS JNWTR_NCHDL
XMN0 N2 A N1 AVSS JNWTR_NCHDL
XMN1 Y C N2 AVSS JNWTR_NCHDL
XMP2 AVDD RN N2 AVDD JNWTR_PCHDL
XMP0 N2 A AVDD AVDD JNWTR_PCHDL
XMP1 Y CN N2 AVDD JNWTR_PCHDL
.ends

* expanding   symbol:  JNW_ATR_SKY130A/JNWATR_PCH_12C1F2.sym # of pins=4
** sym_path: /Users/wulff/data/2023/aicex/ip/lelo_temp_sky130a/design/JNW_ATR_SKY130A/JNWATR_PCH_12C1F2.sym
** sch_path: /Users/wulff/data/2023/aicex/ip/lelo_temp_sky130a/design/JNW_ATR_SKY130A/JNWATR_PCH_12C1F2.sch
.subckt JNWATR_PCH_12C1F2 D G S B
*.iopin D
*.iopin G
*.iopin S
*.iopin B
XM1 D G S B sky130_fd_pr__pfet_01v8 L=0.22 W=8.32 nf=2 ad='int((nf+1)/2) * W/nf * 0.29' as='int((nf+2)/2) * W/nf * 0.29' pd='2*int((nf+1)/2) * (W/nf + 0.29)'
+ ps='2*int((nf+2)/2) * (W/nf + 0.29)' nrd='0.29 / W' nrs='0.29 / W' sa=0 sb=0 sd=0 mult=1 m=1
.ends

* expanding   symbol:  JNW_ATR_SKY130A/JNWATR_PCH_12C5F0.sym # of pins=4
** sym_path: /Users/wulff/data/2023/aicex/ip/lelo_temp_sky130a/design/JNW_ATR_SKY130A/JNWATR_PCH_12C5F0.sym
** sch_path: /Users/wulff/data/2023/aicex/ip/lelo_temp_sky130a/design/JNW_ATR_SKY130A/JNWATR_PCH_12C5F0.sch
.subckt JNWATR_PCH_12C5F0 D G S B
*.iopin D
*.iopin G
*.iopin S
*.iopin B
XM1 D G S B sky130_fd_pr__pfet_01v8 L=0.94 W=8.32 nf=2 ad='int((nf+1)/2) * W/nf * 0.29' as='int((nf+2)/2) * W/nf * 0.29' pd='2*int((nf+1)/2) * (W/nf + 0.29)'
+ ps='2*int((nf+2)/2) * (W/nf + 0.29)' nrd='0.29 / W' nrs='0.29 / W' sa=0 sb=0 sd=0 mult=1 m=1
.ends

* expanding   symbol:  JNW_TR_SKY130A/JNWTR_RPPO2.sym # of pins=3
** sym_path: /Users/wulff/data/2023/aicex/ip/lelo_temp_sky130a/design/JNW_TR_SKY130A/JNWTR_RPPO2.sym
** sch_path: /Users/wulff/data/2023/aicex/ip/lelo_temp_sky130a/design/JNW_TR_SKY130A/JNWTR_RPPO2.sch
.subckt JNWTR_RPPO2 N P B
*.iopin P
*.iopin N
*.iopin B
XXA1 N P B JNWTR_RES2
.ends

* expanding   symbol:  JNW_TR_SKY130A/JNWTR_RES4.sym # of pins=3
** sym_path: /Users/wulff/data/2023/aicex/ip/lelo_temp_sky130a/design/JNW_TR_SKY130A/JNWTR_RES4.sym
** sch_path: /Users/wulff/data/2023/aicex/ip/lelo_temp_sky130a/design/JNW_TR_SKY130A/JNWTR_RES4.sch
.subckt JNWTR_RES4 N P B
*.iopin N
*.iopin P
*.iopin B
XR1_0 INT_0 N B sky130_fd_pr__res_high_po W=0.36 L=7.36 mult=1 m=1
XR1_1 INT_1 INT_0 B sky130_fd_pr__res_high_po W=0.36 L=7.36 mult=1 m=1
XR1_2 INT_2 INT_1 B sky130_fd_pr__res_high_po W=0.36 L=7.36 mult=1 m=1
XR1_3 P INT_2 B sky130_fd_pr__res_high_po W=0.36 L=7.36 mult=1 m=1
.ends

* expanding   symbol:  JNW_TR_SKY130A/JNWTR_RES8.sym # of pins=3
** sym_path: /Users/wulff/data/2023/aicex/ip/lelo_temp_sky130a/design/JNW_TR_SKY130A/JNWTR_RES8.sym
** sch_path: /Users/wulff/data/2023/aicex/ip/lelo_temp_sky130a/design/JNW_TR_SKY130A/JNWTR_RES8.sch
.subckt JNWTR_RES8 N P B
*.iopin N
*.iopin P
*.iopin B
XR1_0 INT_0 N B sky130_fd_pr__res_high_po W=0.36 L=7.36 mult=1 m=1
XR1_1 INT_1 INT_0 B sky130_fd_pr__res_high_po W=0.36 L=7.36 mult=1 m=1
XR1_2 INT_2 INT_1 B sky130_fd_pr__res_high_po W=0.36 L=7.36 mult=1 m=1
XR1_3 INT_3 INT_2 B sky130_fd_pr__res_high_po W=0.36 L=7.36 mult=1 m=1
XR1_4 INT_4 INT_3 B sky130_fd_pr__res_high_po W=0.36 L=7.36 mult=1 m=1
XR1_5 INT_5 INT_4 B sky130_fd_pr__res_high_po W=0.36 L=7.36 mult=1 m=1
XR1_6 INT_6 INT_5 B sky130_fd_pr__res_high_po W=0.36 L=7.36 mult=1 m=1
XR1_7 P INT_6 B sky130_fd_pr__res_high_po W=0.36 L=7.36 mult=1 m=1
.ends

* expanding   symbol:  JNW_TR_SKY130A/JNWTR_RES2.sym # of pins=3
** sym_path: /Users/wulff/data/2023/aicex/ip/lelo_temp_sky130a/design/JNW_TR_SKY130A/JNWTR_RES2.sym
** sch_path: /Users/wulff/data/2023/aicex/ip/lelo_temp_sky130a/design/JNW_TR_SKY130A/JNWTR_RES2.sch
.subckt JNWTR_RES2 N P B
*.iopin N
*.iopin P
*.iopin B
XR1_0 INT_0 N B sky130_fd_pr__res_high_po W=0.36 L=7.36 mult=1 m=1
XR1_1 P INT_0 B sky130_fd_pr__res_high_po W=0.36 L=7.36 mult=1 m=1
.ends

.end
