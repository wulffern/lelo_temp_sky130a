** sch_path: /Users/wulff/data/2023/aicex/ip/lelo_temp_sky130a/design/LELO_TEMP_SKY130A/TB_LELOTEMP_BIAS_IBP_LSTB.sch
**.subckt TB_LELOTEMP_BIAS_IBP_LSTB
V1 VDD_1V8 0 {vdda}
V2 IBP_1U<0> 0 0.5
x1 VDD_1V8 LPI IBP_1U<3> IBP_1U<2> IBP_1U<1> IBP_1U<0> LPO VD1 VDD_1V8 0 0 LELOTEMP_BIAS_IBP
C1 VDD_1V8 LPI 1f m=1
**** begin user architecture code

.lib ../../../tech/ngspice/corners.spi Kfs
.lib ../../../tech/ngspice/temperature.spi Tl
.lib ../../../tech/ngspice/supply.spi Vh
.include ../../../../cpdk/ngspice/tian_subckt.lib
X999 LPI LPO loopgainprobe

.control
optran 0 0 0 10n 20u 0
save alli
save allv
save @m.*[gm]
op
remzerovec
write TB_LELOTEMP_BIAS_IBP_LSTB_OP.raw
unsave all

save allv
save i(v1) i(v2)
* Set voltage AC to 1
ac dec 50 100 1G
* Set Current to 1
alter i.X999.Ii acmag=1
alter v.X999.Vi acmag=0
ac dec 50 100 1G
let lg_mag = db(tian_loop())
let lg_phase = 180*cph(tian_loop())/pi
remzerovec
write TB_LELOTEMP_BIAS_IBP_LSTB.raw

meas ac gm_db find lg_mag when lg_phase=0
meas ac pm_deg find lg_phase when lg_mag=0
meas ac f3db when lg_phase=135
meas ac ug when lg_mag=0
meas ac lf_gain find lg_mag at=1k
remzerovec
write TB_LELOTEMP_BIAS_IBP_LSTB_meas.raw
exit
.endc
.end

**** end user architecture code
**.ends

* expanding   symbol:  LELO_TEMP_SKY130A/LELOTEMP_BIAS_IBP.sym # of pins=8
** sym_path: /Users/wulff/data/2023/aicex/ip/lelo_temp_sky130a/design/LELO_TEMP_SKY130A/LELOTEMP_BIAS_IBP.sym
** sch_path: /Users/wulff/data/2023/aicex/ip/lelo_temp_sky130a/design/LELO_TEMP_SKY130A/LELOTEMP_BIAS_IBP.sch
.subckt LELOTEMP_BIAS_IBP VDD_1V8 LPI IBP_1U<3> IBP_1U<2> IBP_1U<1> IBP_1U<0> LPO VD1 PWRUP_1V8 VSS PWRUP_N_1V8
*.ipin VDD_1V8
*.ipin VSS
*.ipin LPI
*.opin LPO
*.opin IBP_1U<3>,IBP_1U<2>,IBP_1U<1>,IBP_1U<0>
*.opin VD1
*.ipin PWRUP_1V8
*.ipin PWRUP_N_1V8
xca2 VBD2 LPI VDD_1V8 VDD_1V8 JNWATR_PCH_4C5F0
xca1<7> VBD1 LPI VDD_1V8 VDD_1V8 JNWATR_PCH_4C5F0
xca1<6> VBD1 LPI VDD_1V8 VDD_1V8 JNWATR_PCH_4C5F0
xca1<5> VBD1 LPI VDD_1V8 VDD_1V8 JNWATR_PCH_4C5F0
xca1<4> VBD1 LPI VDD_1V8 VDD_1V8 JNWATR_PCH_4C5F0
xca1<3> VBD1 LPI VDD_1V8 VDD_1V8 JNWATR_PCH_4C5F0
xca1<2> VBD1 LPI VDD_1V8 VDD_1V8 JNWATR_PCH_4C5F0
xca1<1> VBD1 LPI VDD_1V8 VDD_1V8 JNWATR_PCH_4C5F0
xca1<0> VBD1 LPI VDD_1V8 VDD_1V8 JNWATR_PCH_4C5F0
xd1<9> LPI VDD_1V8 JNWTR_CAPX1
xd1<8> LPI VDD_1V8 JNWTR_CAPX1
xd1<7> LPI VDD_1V8 JNWTR_CAPX1
xd1<6> LPI VDD_1V8 JNWTR_CAPX1
xd1<5> LPI VDD_1V8 JNWTR_CAPX1
xd1<4> LPI VDD_1V8 JNWTR_CAPX1
xd1<3> LPI VDD_1V8 JNWTR_CAPX1
xd1<2> LPI VDD_1V8 JNWTR_CAPX1
xd1<1> LPI VDD_1V8 JNWTR_CAPX1
xd1<0> LPI VDD_1V8 JNWTR_CAPX1
xad6 VDD_1V8 VR1 LPO VD1 VSS PWRUP_1V8 PWRUP_N_1V8 VCP LELOTEMP_OTA
xca3<3> IBD<3> LPI VDD_1V8 VDD_1V8 JNWATR_PCH_4C5F0
xca3<2> IBD<2> LPI VDD_1V8 VDD_1V8 JNWATR_PCH_4C5F0
xca3<1> IBD<1> LPI VDD_1V8 VDD_1V8 JNWATR_PCH_4C5F0
xca3<0> IBD<0> LPI VDD_1V8 VDD_1V8 JNWATR_PCH_4C5F0
xrac2 VD2 net1 VSS JNWTR_RPPO4
xe1 VD2 VD1 VSS JNWBIAS_BIPOLAR
xg1 VR1 VR1 VD2 VSS JNWATR_NCH_4C5F0
xrac3 net1 VR1 VSS JNWTR_RPPO8
xcc<4> VDD_1V8 VDD_1V8 VDD_1V8 VDD_1V8 JNWATR_PCH_4C5F0
xcc<3> VDD_1V8 VDD_1V8 VDD_1V8 VDD_1V8 JNWATR_PCH_4C5F0
xcc<2> VDD_1V8 VDD_1V8 VDD_1V8 VDD_1V8 JNWATR_PCH_4C5F0
xcc<1> VDD_1V8 VDD_1V8 VDD_1V8 VDD_1V8 JNWATR_PCH_4C5F0
xcc<0> VDD_1V8 VDD_1V8 VDD_1V8 VDD_1V8 JNWATR_PCH_4C5F0
xca2<3> IBP_1U<3> VCP IBD<3> VDD_1V8 JNWATR_PCH_4C1F2
xca2<2> IBP_1U<2> VCP IBD<2> VDD_1V8 JNWATR_PCH_4C1F2
xca2<1> IBP_1U<1> VCP IBD<1> VDD_1V8 JNWATR_PCH_4C1F2
xca2<0> IBP_1U<0> VCP IBD<0> VDD_1V8 JNWATR_PCH_4C1F2
xca4 VR1 VCP VBD2 VDD_1V8 JNWATR_PCH_4C1F2
xca5<7> VD1 VCP VBD1 VDD_1V8 JNWATR_PCH_4C1F2
xca5<6> VD1 VCP VBD1 VDD_1V8 JNWATR_PCH_4C1F2
xca5<5> VD1 VCP VBD1 VDD_1V8 JNWATR_PCH_4C1F2
xca5<4> VD1 VCP VBD1 VDD_1V8 JNWATR_PCH_4C1F2
xca5<3> VD1 VCP VBD1 VDD_1V8 JNWATR_PCH_4C1F2
xca5<2> VD1 VCP VBD1 VDD_1V8 JNWATR_PCH_4C1F2
xca5<1> VD1 VCP VBD1 VDD_1V8 JNWATR_PCH_4C1F2
xca5<0> VD1 VCP VBD1 VDD_1V8 JNWATR_PCH_4C1F2
xd2<2> VCP VDD_1V8 JNWTR_CAPX1
xd2<1> VCP VDD_1V8 JNWTR_CAPX1
xd2<0> VCP VDD_1V8 JNWTR_CAPX1
xsu1 VSU VSU VDD_1V8 VDD_1V8 JNWATR_PCH_2C5F0
xsu2 VD1 VD1 VSU VDD_1V8 JNWATR_PCH_2C5F0
.ends

* expanding   symbol:  JNW_ATR_SKY130A/JNWATR_PCH_4C5F0.sym # of pins=4
** sym_path: /Users/wulff/data/2023/aicex/ip/lelo_temp_sky130a/design/JNW_ATR_SKY130A/JNWATR_PCH_4C5F0.sym
** sch_path: /Users/wulff/data/2023/aicex/ip/lelo_temp_sky130a/design/JNW_ATR_SKY130A/JNWATR_PCH_4C5F0.sch
.subckt JNWATR_PCH_4C5F0 D G S B
*.iopin D
*.iopin G
*.iopin S
*.iopin B
XM1 D G S B sky130_fd_pr__pfet_01v8 L=0.94 W=3.2 nf=2 ad='int((nf+1)/2) * W/nf * 0.29' as='int((nf+2)/2) * W/nf * 0.29' pd='2*int((nf+1)/2) * (W/nf + 0.29)'
+ ps='2*int((nf+2)/2) * (W/nf + 0.29)' nrd='0.29 / W' nrs='0.29 / W' sa=0 sb=0 sd=0 mult=1 m=1
.ends

* expanding   symbol:  JNW_TR_SKY130A/JNWTR_CAPX1.sym # of pins=2
** sym_path: /Users/wulff/data/2023/aicex/ip/lelo_temp_sky130a/design/JNW_TR_SKY130A/JNWTR_CAPX1.sym
** sch_path: /Users/wulff/data/2023/aicex/ip/lelo_temp_sky130a/design/JNW_TR_SKY130A/JNWTR_CAPX1.sch
.subckt JNWTR_CAPX1 A B
*.iopin A
*.iopin B
XC1 B A sky130_fd_pr__cap_mim_m3_1 W=5 L=5 MF=1 m=1
.ends

* expanding   symbol:  LELO_TEMP_SKY130A/LELOTEMP_OTA.sym # of pins=8
** sym_path: /Users/wulff/data/2023/aicex/ip/lelo_temp_sky130a/design/LELO_TEMP_SKY130A/LELOTEMP_OTA.sym
** sch_path: /Users/wulff/data/2023/aicex/ip/lelo_temp_sky130a/design/LELO_TEMP_SKY130A/LELOTEMP_OTA.sch
.subckt LELOTEMP_OTA VDD_1V8 VIP VO VIN VSS PWRUP_1V8 PWRUP_N_1V8 VCP
*.opin VO
*.ipin VIP
*.ipin VIN
*.ipin VDD_1V8
*.ipin VSS
*.ipin PWRUP_N_1V8
*.ipin PWRUP_1V8
*.opin VCP
xnd1<3> VD1 VD1 VSS VSS JNWATR_NCH_4C5F0
xnd1<2> VD1 VD1 VSS VSS JNWATR_NCH_4C5F0
xnd1<1> VD1 VD1 VSS VSS JNWATR_NCH_4C5F0
xnd1<0> VD1 VD1 VSS VSS JNWATR_NCH_4C5F0
xnd2<3> VD2 VD2 VSS VSS JNWATR_NCH_4C5F0
xnd2<2> VD2 VD2 VSS VSS JNWATR_NCH_4C5F0
xnd2<1> VD2 VD2 VSS VSS JNWATR_NCH_4C5F0
xnd2<0> VD2 VD2 VSS VSS JNWATR_NCH_4C5F0
xba6 VBP VBP VDD_1V8 VDD_1V8 JNWATR_PCH_12C5F0
xnd3 VBP VD1 VSS VSS JNWATR_NCH_4C5F0
xba8 VO VBP VDD_1V8 VDD_1V8 JNWATR_PCH_12C5F0
xnd4 VO VD2 VSS VSS JNWATR_NCH_4C5F0
xd2 net1 VS VSS JNWTR_RPPO8
xba7 VBP PWRUP_1V8 VDD_1V8 VDD_1V8 JNWATR_PCH_12C5F0
xba1 net1 PWRUP_N_1V8 VDD_1V8 VDD_1V8 JNWATR_PCH_12C5F0
xba2 VO PWRUP_1V8 VDD_1V8 VDD_1V8 JNWATR_PCH_12C5F0
xns1 VD1 PWRUP_N_1V8 VSS VSS JNWATR_NCH_4C5F0
xns2 VD2 PWRUP_N_1V8 VSS VSS JNWATR_NCH_4C5F0
xnc0 VD3 VD3 VSS VSS JNWATR_NCH_4C5F0
xnc1<2> VCP VD3 VSS VSS JNWATR_NCH_4C5F0
xnc1<1> VCP VD3 VSS VSS JNWATR_NCH_4C5F0
xnc1<0> VCP VD3 VSS VSS JNWATR_NCH_4C5F0
xbs6 net2 VCP VDD_1V8 VDD_1V8 JNWATR_PCH_4C1F2
xbs1 net3 VCP net2 VDD_1V8 JNWATR_PCH_4C1F2
xbs2 net5 VCP net3 VDD_1V8 JNWATR_PCH_4C1F2
xbs4 net4 VCP net5 VDD_1V8 JNWATR_PCH_4C1F2
xbs7 net6 VCP net4 VDD_1V8 JNWATR_PCH_4C1F2
xns4 VD3 PWRUP_N_1V8 VSS VSS JNWATR_NCH_4C5F0
xba3 VCP PWRUP_1V8 VDD_1V8 VDD_1V8 JNWATR_PCH_12C5F0
xbs8 VCP VCP net6 VDD_1V8 JNWATR_PCH_4C1F2
xbl1<3> VD1 VIN VS VDD_1V8 LELOATR_LVT_PCH_12C5F0
xbl1<2> VD1 VIN VS VDD_1V8 LELOATR_LVT_PCH_12C5F0
xbl1<1> VD1 VIN VS VDD_1V8 LELOATR_LVT_PCH_12C5F0
xbl1<0> VD1 VIN VS VDD_1V8 LELOATR_LVT_PCH_12C5F0
xbl0<3> VD2 VIP VS VDD_1V8 LELOATR_LVT_PCH_12C5F0
xbl0<2> VD2 VIP VS VDD_1V8 LELOATR_LVT_PCH_12C5F0
xbl0<1> VD2 VIP VS VDD_1V8 LELOATR_LVT_PCH_12C5F0
xbl0<0> VD2 VIP VS VDD_1V8 LELOATR_LVT_PCH_12C5F0
xbl4 VD3 VIN VS VDD_1V8 LELOATR_LVT_PCH_12C5F0
xbl5 VD3 VIP VS VDD_1V8 LELOATR_LVT_PCH_12C5F0
.ends

* expanding   symbol:  JNW_TR_SKY130A/JNWTR_RPPO4.sym # of pins=3
** sym_path: /Users/wulff/data/2023/aicex/ip/lelo_temp_sky130a/design/JNW_TR_SKY130A/JNWTR_RPPO4.sym
** sch_path: /Users/wulff/data/2023/aicex/ip/lelo_temp_sky130a/design/JNW_TR_SKY130A/JNWTR_RPPO4.sch
.subckt JNWTR_RPPO4 N P B
*.iopin P
*.iopin N
*.iopin B
XXA1 N P B JNWTR_RES4
.ends

* expanding   symbol:  JNW_BIAS_SKY130A/JNWBIAS_BIPOLAR.sym # of pins=3
** sym_path: /Users/wulff/data/2023/aicex/ip/lelo_temp_sky130a/design/JNW_BIAS_SKY130A/JNWBIAS_BIPOLAR.sym
** sch_path: /Users/wulff/data/2023/aicex/ip/lelo_temp_sky130a/design/JNW_BIAS_SKY130A/JNWBIAS_BIPOLAR.sch
.subckt JNWBIAS_BIPOLAR VD2 VD1 VSS
*.ipin VSS
*.ipin VD1
*.ipin VD2
XQ1 VSS VSS VD1 sky130_fd_pr__pnp_05v5_W3p40L3p40 m=1 mult=1
XQ2<7> VSS VSS VD2 sky130_fd_pr__pnp_05v5_W3p40L3p40 m=1 mult=1
XQ2<6> VSS VSS VD2 sky130_fd_pr__pnp_05v5_W3p40L3p40 m=1 mult=1
XQ2<5> VSS VSS VD2 sky130_fd_pr__pnp_05v5_W3p40L3p40 m=1 mult=1
XQ2<4> VSS VSS VD2 sky130_fd_pr__pnp_05v5_W3p40L3p40 m=1 mult=1
XQ2<3> VSS VSS VD2 sky130_fd_pr__pnp_05v5_W3p40L3p40 m=1 mult=1
XQ2<2> VSS VSS VD2 sky130_fd_pr__pnp_05v5_W3p40L3p40 m=1 mult=1
XQ2<1> VSS VSS VD2 sky130_fd_pr__pnp_05v5_W3p40L3p40 m=1 mult=1
XQ2<0> VSS VSS VD2 sky130_fd_pr__pnp_05v5_W3p40L3p40 m=1 mult=1
.ends

* expanding   symbol:  JNW_ATR_SKY130A/JNWATR_NCH_4C5F0.sym # of pins=4
** sym_path: /Users/wulff/data/2023/aicex/ip/lelo_temp_sky130a/design/JNW_ATR_SKY130A/JNWATR_NCH_4C5F0.sym
** sch_path: /Users/wulff/data/2023/aicex/ip/lelo_temp_sky130a/design/JNW_ATR_SKY130A/JNWATR_NCH_4C5F0.sch
.subckt JNWATR_NCH_4C5F0 D G S B
*.iopin D
*.iopin G
*.iopin S
*.iopin B
XM1 D G S B sky130_fd_pr__nfet_01v8 L=0.94 W=3.2 nf=2 ad='int((nf+1)/2) * W/nf * 0.29' as='int((nf+2)/2) * W/nf * 0.29' pd='2*int((nf+1)/2) * (W/nf + 0.29)'
+ ps='2*int((nf+2)/2) * (W/nf + 0.29)' nrd='0.29 / W' nrs='0.29 / W' sa=0 sb=0 sd=0 mult=1 m=1
.ends

* expanding   symbol:  JNW_TR_SKY130A/JNWTR_RPPO8.sym # of pins=3
** sym_path: /Users/wulff/data/2023/aicex/ip/lelo_temp_sky130a/design/JNW_TR_SKY130A/JNWTR_RPPO8.sym
** sch_path: /Users/wulff/data/2023/aicex/ip/lelo_temp_sky130a/design/JNW_TR_SKY130A/JNWTR_RPPO8.sch
.subckt JNWTR_RPPO8 N P B
*.iopin P
*.iopin N
*.iopin B
XXA1 N P B JNWTR_RES8
.ends

* expanding   symbol:  JNW_ATR_SKY130A/JNWATR_PCH_4C1F2.sym # of pins=4
** sym_path: /Users/wulff/data/2023/aicex/ip/lelo_temp_sky130a/design/JNW_ATR_SKY130A/JNWATR_PCH_4C1F2.sym
** sch_path: /Users/wulff/data/2023/aicex/ip/lelo_temp_sky130a/design/JNW_ATR_SKY130A/JNWATR_PCH_4C1F2.sch
.subckt JNWATR_PCH_4C1F2 D G S B
*.iopin D
*.iopin G
*.iopin S
*.iopin B
XM1 D G S B sky130_fd_pr__pfet_01v8 L=0.22 W=3.2 nf=2 ad='int((nf+1)/2) * W/nf * 0.29' as='int((nf+2)/2) * W/nf * 0.29' pd='2*int((nf+1)/2) * (W/nf + 0.29)'
+ ps='2*int((nf+2)/2) * (W/nf + 0.29)' nrd='0.29 / W' nrs='0.29 / W' sa=0 sb=0 sd=0 mult=1 m=1
.ends

* expanding   symbol:  JNW_ATR_SKY130A/JNWATR_PCH_2C5F0.sym # of pins=4
** sym_path: /Users/wulff/data/2023/aicex/ip/lelo_temp_sky130a/design/JNW_ATR_SKY130A/JNWATR_PCH_2C5F0.sym
** sch_path: /Users/wulff/data/2023/aicex/ip/lelo_temp_sky130a/design/JNW_ATR_SKY130A/JNWATR_PCH_2C5F0.sch
.subckt JNWATR_PCH_2C5F0 D G S B
*.iopin D
*.iopin G
*.iopin S
*.iopin B
XM1 D G S B sky130_fd_pr__pfet_01v8 L=0.94 W=1.92 nf=2 ad='int((nf+1)/2) * W/nf * 0.29' as='int((nf+2)/2) * W/nf * 0.29' pd='2*int((nf+1)/2) * (W/nf + 0.29)'
+ ps='2*int((nf+2)/2) * (W/nf + 0.29)' nrd='0.29 / W' nrs='0.29 / W' sa=0 sb=0 sd=0 mult=1 m=1
.ends

* expanding   symbol:  JNW_ATR_SKY130A/JNWATR_PCH_12C5F0.sym # of pins=4
** sym_path: /Users/wulff/data/2023/aicex/ip/lelo_temp_sky130a/design/JNW_ATR_SKY130A/JNWATR_PCH_12C5F0.sym
** sch_path: /Users/wulff/data/2023/aicex/ip/lelo_temp_sky130a/design/JNW_ATR_SKY130A/JNWATR_PCH_12C5F0.sch
.subckt JNWATR_PCH_12C5F0 D G S B
*.iopin D
*.iopin G
*.iopin S
*.iopin B
XM1 D G S B sky130_fd_pr__pfet_01v8 L=0.94 W=8.32 nf=2 ad='int((nf+1)/2) * W/nf * 0.29' as='int((nf+2)/2) * W/nf * 0.29' pd='2*int((nf+1)/2) * (W/nf + 0.29)'
+ ps='2*int((nf+2)/2) * (W/nf + 0.29)' nrd='0.29 / W' nrs='0.29 / W' sa=0 sb=0 sd=0 mult=1 m=1
.ends

* expanding   symbol:  LELO_ATR_SKY130A/LELOATR_LVT_PCH_12C5F0.sym # of pins=4
** sym_path: /Users/wulff/data/2023/aicex/ip/lelo_temp_sky130a/design/LELO_ATR_SKY130A/LELOATR_LVT_PCH_12C5F0.sym
** sch_path: /Users/wulff/data/2023/aicex/ip/lelo_temp_sky130a/design/LELO_ATR_SKY130A/LELOATR_LVT_PCH_12C5F0.sch
.subckt LELOATR_LVT_PCH_12C5F0 D G S B
*.iopin D
*.iopin G
*.iopin S
*.iopin B
XM1 D G S B sky130_fd_pr__pfet_01v8_lvt L=0.94 W=8.32 nf=2 ad='int((nf+1)/2) * W/nf * 0.29' as='int((nf+2)/2) * W/nf * 0.29' pd='2*int((nf+1)/2) * (W/nf + 0.29)'
+ ps='2*int((nf+2)/2) * (W/nf + 0.29)' nrd='0.29 / W' nrs='0.29 / W' sa=0 sb=0 sd=0 mult=1 m=1
.ends

* expanding   symbol:  JNW_TR_SKY130A/JNWTR_RES4.sym # of pins=3
** sym_path: /Users/wulff/data/2023/aicex/ip/lelo_temp_sky130a/design/JNW_TR_SKY130A/JNWTR_RES4.sym
** sch_path: /Users/wulff/data/2023/aicex/ip/lelo_temp_sky130a/design/JNW_TR_SKY130A/JNWTR_RES4.sch
.subckt JNWTR_RES4 N P B
*.iopin N
*.iopin P
*.iopin B
XR1_0 INT_0 N B sky130_fd_pr__res_high_po W=0.36 L=7.36 mult=1 m=1
XR1_1 INT_1 INT_0 B sky130_fd_pr__res_high_po W=0.36 L=7.36 mult=1 m=1
XR1_2 INT_2 INT_1 B sky130_fd_pr__res_high_po W=0.36 L=7.36 mult=1 m=1
XR1_3 P INT_2 B sky130_fd_pr__res_high_po W=0.36 L=7.36 mult=1 m=1
.ends

* expanding   symbol:  JNW_TR_SKY130A/JNWTR_RES8.sym # of pins=3
** sym_path: /Users/wulff/data/2023/aicex/ip/lelo_temp_sky130a/design/JNW_TR_SKY130A/JNWTR_RES8.sym
** sch_path: /Users/wulff/data/2023/aicex/ip/lelo_temp_sky130a/design/JNW_TR_SKY130A/JNWTR_RES8.sch
.subckt JNWTR_RES8 N P B
*.iopin N
*.iopin P
*.iopin B
XR1_0 INT_0 N B sky130_fd_pr__res_high_po W=0.36 L=7.36 mult=1 m=1
XR1_1 INT_1 INT_0 B sky130_fd_pr__res_high_po W=0.36 L=7.36 mult=1 m=1
XR1_2 INT_2 INT_1 B sky130_fd_pr__res_high_po W=0.36 L=7.36 mult=1 m=1
XR1_3 INT_3 INT_2 B sky130_fd_pr__res_high_po W=0.36 L=7.36 mult=1 m=1
XR1_4 INT_4 INT_3 B sky130_fd_pr__res_high_po W=0.36 L=7.36 mult=1 m=1
XR1_5 INT_5 INT_4 B sky130_fd_pr__res_high_po W=0.36 L=7.36 mult=1 m=1
XR1_6 INT_6 INT_5 B sky130_fd_pr__res_high_po W=0.36 L=7.36 mult=1 m=1
XR1_7 P INT_6 B sky130_fd_pr__res_high_po W=0.36 L=7.36 mult=1 m=1
.ends

.end
