** sch_path: /Users/wulff/data/2023/aicex/ip/lelo_temp_sky130a/design/LELO_TEMP_SKY130A/TB_LELO_TEMP.sch
**.subckt TB_LELO_TEMP
xdut VDD_1V8 OSC_TEMP_1V8 PWRUP_1V8 0 LELO_TEMP
V1 VDD_1V8 0 pwl 0 0 0.5u 0 1.5u {VDDA}
V2 PWRUP_1V8 0 pwl 0 0 2u 0 2.01u {VDDA}
**** begin user architecture code

.param mc_mm_switch=0
.param mc_pr_switch=0

.lib ../../../tech/ngspice/temperature.spi Tt
.lib ../../../tech/ngspice/corners.spi Ktt
.lib ../../../tech/ngspice/supply.spi Vt
.include ../../../../cpdk/ngspice/ideal_circuits.spi

.option SEED=1
.option savecurrents
.save all
.control
optran 0 0 0 10n 1u 0
unset askquit

tran 2n 8u
remzerovec

write TB_LELO_TEMP_tran.raw

exit
.endc

**** end user architecture code
**.ends

* expanding   symbol:  LELO_TEMP_SKY130A/LELO_TEMP.sym # of pins=4
** sym_path: /Users/wulff/data/2023/aicex/ip/lelo_temp_sky130a/design/LELO_TEMP_SKY130A/LELO_TEMP.sym
** sch_path: /Users/wulff/data/2023/aicex/ip/lelo_temp_sky130a/design/LELO_TEMP_SKY130A/LELO_TEMP.sch
.subckt LELO_TEMP VDD_1V8 OSC_TEMP_1V8 PWRUP_1V8 VSS
*.ipin VDD_1V8
*.ipin VSS
*.ipin PWRUP_1V8
*.opin OSC_TEMP_1V8
x1_ibp VDD_1V8 LPI IBP_1U<3> IBP_1U<2> IBP_1U<1> IBP_1U<0> LPI VC PWRUP_B_1V8 VSS PWRUP_N_1V8 LELOTEMP_BIAS_IBP
x6 PWRUP_1V8 PWRUP_N_1V8 VDD_1V8 VSS JNWTR_IVX1_CV
x2 PWRUP_N_1V8 PWRUP_B_1V8 VDD_1V8 VSS JNWTR_IVX1_CV
x3 net1 RST_A RST_B VDD_1V8 VSS JNWTR_NRX1_CV
x4 RST_B net2 RST_A VDD_1V8 VSS JNWTR_NRX1_CV
x5 RST_B OSC_TEMP_1V8 VDD_1V8 VSS JNWTR_BFX1_CV
x7 CMPO_B PWRUP_N_1V8 net1 VDD_1V8 VSS JNWTR_ORX1_CV
x3_ccmp IBP_1U<1> IBP_1U<0> VDD_1V8 PWRUP_N_1V8 PWRUP_B_1V8 CMPO_B VC RST_A VSS LELOTEMP_CCMP
x2_ccmp IBP_1U<3> IBP_1U<2> VDD_1V8 PWRUP_N_1V8 PWRUP_B_1V8 CMPO_A VC RST_B VSS LELOTEMP_CCMP
x1 CMPO_A net2 VDD_1V8 VSS JNWTR_BFX1_CV
.ends

* expanding   symbol:  LELO_TEMP_SKY130A/LELOTEMP_BIAS_IBP.sym # of pins=8
** sym_path: /Users/wulff/data/2023/aicex/ip/lelo_temp_sky130a/design/LELO_TEMP_SKY130A/LELOTEMP_BIAS_IBP.sym
** sch_path: /Users/wulff/data/2023/aicex/ip/lelo_temp_sky130a/design/LELO_TEMP_SKY130A/LELOTEMP_BIAS_IBP.sch
.subckt LELOTEMP_BIAS_IBP VDD_1V8 LPI IBP_1U<3> IBP_1U<2> IBP_1U<1> IBP_1U<0> LPO VD1 PWRUP_1V8 VSS PWRUP_N_1V8
*.ipin VDD_1V8
*.ipin VSS
*.ipin LPI
*.opin LPO
*.opin IBP_1U<3>,IBP_1U<2>,IBP_1U<1>,IBP_1U<0>
*.opin VD1
*.ipin PWRUP_1V8
*.ipin PWRUP_N_1V8
xca2 VBD2 LPI VDD_1V8 VDD_1V8 JNWATR_PCH_4C5F0
xca1<7> VBD1 LPI VDD_1V8 VDD_1V8 JNWATR_PCH_4C5F0
xca1<6> VBD1 LPI VDD_1V8 VDD_1V8 JNWATR_PCH_4C5F0
xca1<5> VBD1 LPI VDD_1V8 VDD_1V8 JNWATR_PCH_4C5F0
xca1<4> VBD1 LPI VDD_1V8 VDD_1V8 JNWATR_PCH_4C5F0
xca1<3> VBD1 LPI VDD_1V8 VDD_1V8 JNWATR_PCH_4C5F0
xca1<2> VBD1 LPI VDD_1V8 VDD_1V8 JNWATR_PCH_4C5F0
xca1<1> VBD1 LPI VDD_1V8 VDD_1V8 JNWATR_PCH_4C5F0
xca1<0> VBD1 LPI VDD_1V8 VDD_1V8 JNWATR_PCH_4C5F0
xd1<9> LPI VDD_1V8 JNWTR_CAPX1
xd1<8> LPI VDD_1V8 JNWTR_CAPX1
xd1<7> LPI VDD_1V8 JNWTR_CAPX1
xd1<6> LPI VDD_1V8 JNWTR_CAPX1
xd1<5> LPI VDD_1V8 JNWTR_CAPX1
xd1<4> LPI VDD_1V8 JNWTR_CAPX1
xd1<3> LPI VDD_1V8 JNWTR_CAPX1
xd1<2> LPI VDD_1V8 JNWTR_CAPX1
xd1<1> LPI VDD_1V8 JNWTR_CAPX1
xd1<0> LPI VDD_1V8 JNWTR_CAPX1
xad6 VDD_1V8 VR1 LPO VD1 VSS PWRUP_1V8 PWRUP_N_1V8 VCP LELOTEMP_OTA
xca3<3> IBD<3> LPI VDD_1V8 VDD_1V8 JNWATR_PCH_4C5F0
xca3<2> IBD<2> LPI VDD_1V8 VDD_1V8 JNWATR_PCH_4C5F0
xca3<1> IBD<1> LPI VDD_1V8 VDD_1V8 JNWATR_PCH_4C5F0
xca3<0> IBD<0> LPI VDD_1V8 VDD_1V8 JNWATR_PCH_4C5F0
xrac2 VD2 net1 VSS JNWTR_RPPO4
xe1 VD2 VD1 VSS JNWBIAS_BIPOLAR
xg1 VR1 VR1 VD2 VSS JNWATR_NCH_4C5F0
xrac3 net1 VR1 VSS JNWTR_RPPO8
xcc<4> VDD_1V8 VDD_1V8 VDD_1V8 VDD_1V8 JNWATR_PCH_4C5F0
xcc<3> VDD_1V8 VDD_1V8 VDD_1V8 VDD_1V8 JNWATR_PCH_4C5F0
xcc<2> VDD_1V8 VDD_1V8 VDD_1V8 VDD_1V8 JNWATR_PCH_4C5F0
xcc<1> VDD_1V8 VDD_1V8 VDD_1V8 VDD_1V8 JNWATR_PCH_4C5F0
xcc<0> VDD_1V8 VDD_1V8 VDD_1V8 VDD_1V8 JNWATR_PCH_4C5F0
xca2<3> IBP_1U<3> VCP IBD<3> VDD_1V8 JNWATR_PCH_4C1F2
xca2<2> IBP_1U<2> VCP IBD<2> VDD_1V8 JNWATR_PCH_4C1F2
xca2<1> IBP_1U<1> VCP IBD<1> VDD_1V8 JNWATR_PCH_4C1F2
xca2<0> IBP_1U<0> VCP IBD<0> VDD_1V8 JNWATR_PCH_4C1F2
xca4 VR1 VCP VBD2 VDD_1V8 JNWATR_PCH_4C1F2
xca5<7> VD1 VCP VBD1 VDD_1V8 JNWATR_PCH_4C1F2
xca5<6> VD1 VCP VBD1 VDD_1V8 JNWATR_PCH_4C1F2
xca5<5> VD1 VCP VBD1 VDD_1V8 JNWATR_PCH_4C1F2
xca5<4> VD1 VCP VBD1 VDD_1V8 JNWATR_PCH_4C1F2
xca5<3> VD1 VCP VBD1 VDD_1V8 JNWATR_PCH_4C1F2
xca5<2> VD1 VCP VBD1 VDD_1V8 JNWATR_PCH_4C1F2
xca5<1> VD1 VCP VBD1 VDD_1V8 JNWATR_PCH_4C1F2
xca5<0> VD1 VCP VBD1 VDD_1V8 JNWATR_PCH_4C1F2
xd2<2> VCP VDD_1V8 JNWTR_CAPX1
xd2<1> VCP VDD_1V8 JNWTR_CAPX1
xd2<0> VCP VDD_1V8 JNWTR_CAPX1
xsu1 VSU VSU VDD_1V8 VDD_1V8 JNWATR_PCH_2C5F0
xsu2 VD1 VD1 VSU VDD_1V8 JNWATR_PCH_2C5F0
.ends

* expanding   symbol:  JNW_TR_SKY130A/JNWTR_IVX1_CV.sym # of pins=4
** sym_path: /Users/wulff/data/2023/aicex/ip/lelo_temp_sky130a/design/JNW_TR_SKY130A/JNWTR_IVX1_CV.sym
** sch_path: /Users/wulff/data/2023/aicex/ip/lelo_temp_sky130a/design/JNW_TR_SKY130A/JNWTR_IVX1_CV.sch
.subckt JNWTR_IVX1_CV A Y AVDD AVSS
*.ipin A
*.opin Y
*.ipin AVDD
*.ipin AVSS
XMN0 Y A AVSS AVSS JNWTR_NCHDL
XMP0 Y A AVDD AVDD JNWTR_PCHDL
.ends

* expanding   symbol:  JNW_TR_SKY130A/JNWTR_NRX1_CV.sym # of pins=5
** sym_path: /Users/wulff/data/2023/aicex/ip/lelo_temp_sky130a/design/JNW_TR_SKY130A/JNWTR_NRX1_CV.sym
** sch_path: /Users/wulff/data/2023/aicex/ip/lelo_temp_sky130a/design/JNW_TR_SKY130A/JNWTR_NRX1_CV.sch
.subckt JNWTR_NRX1_CV A B Y AVDD AVSS
*.iopin A
*.iopin B
*.iopin Y
*.iopin AVDD
*.iopin AVSS
XMN0 Y A AVSS AVSS JNWTR_NCHDL
XMN1 AVSS B Y AVSS JNWTR_NCHDL
XMP0 N1 A AVDD AVDD JNWTR_PCHDL
XMP1 Y B N1 AVDD JNWTR_PCHDL
.ends

* expanding   symbol:  JNW_TR_SKY130A/JNWTR_BFX1_CV.sym # of pins=4
** sym_path: /Users/wulff/data/2023/aicex/ip/lelo_temp_sky130a/design/JNW_TR_SKY130A/JNWTR_BFX1_CV.sym
** sch_path: /Users/wulff/data/2023/aicex/ip/lelo_temp_sky130a/design/JNW_TR_SKY130A/JNWTR_BFX1_CV.sch
.subckt JNWTR_BFX1_CV A Y AVDD AVSS
*.ipin A
*.opin Y
*.ipin AVDD
*.ipin AVSS
XMN0 AVSS A B AVSS JNWTR_NCHDL
XMN1 Y B AVSS AVSS JNWTR_NCHDL
XMP0 AVDD A B AVDD JNWTR_PCHDL
XMP1 Y B AVDD AVDD JNWTR_PCHDL
.ends

* expanding   symbol:  JNW_TR_SKY130A/JNWTR_ORX1_CV.sym # of pins=5
** sym_path: /Users/wulff/data/2023/aicex/ip/lelo_temp_sky130a/design/JNW_TR_SKY130A/JNWTR_ORX1_CV.sym
** sch_path: /Users/wulff/data/2023/aicex/ip/lelo_temp_sky130a/design/JNW_TR_SKY130A/JNWTR_ORX1_CV.sch
.subckt JNWTR_ORX1_CV A B Y AVDD AVSS
*.iopin A
*.iopin B
*.iopin Y
*.iopin AVDD
*.iopin AVSS
XXA1 A B YN AVDD AVSS JNWTR_NRX1_CV
XXA2 YN Y AVDD AVSS JNWTR_IVX1_CV
.ends

* expanding   symbol:  LELO_TEMP_SKY130A/LELOTEMP_CCMP.sym # of pins=8
** sym_path: /Users/wulff/data/2023/aicex/ip/lelo_temp_sky130a/design/LELO_TEMP_SKY130A/LELOTEMP_CCMP.sym
** sch_path: /Users/wulff/data/2023/aicex/ip/lelo_temp_sky130a/design/LELO_TEMP_SKY130A/LELOTEMP_CCMP.sch
.subckt LELOTEMP_CCMP IBP_1U<1> IBP_1U<0> VDD_1V8 PWRUP_N_1V8 PWRUP_B_1V8 CMPO VC RST VSS
*.ipin VDD_1V8
*.ipin PWRUP_B_1V8
*.ipin PWRUP_N_1V8
*.ipin VSS
*.ipin IBP_1U<1>,IBP_1U<0>
*.opin CMPO
*.ipin VC
*.ipin RST
xd1<4> IBP_1U<0> VSS JNWTR_CAPX1
xd1<3> IBP_1U<0> VSS JNWTR_CAPX1
xd1<2> IBP_1U<0> VSS JNWTR_CAPX1
xd1<1> IBP_1U<0> VSS JNWTR_CAPX1
xd1<0> IBP_1U<0> VSS JNWTR_CAPX1
xg1 IBP_1U<0> RST VSS VSS JNWATR_NCH_2C5F0
x1_cmp VDD_1V8 IBP_1U<0> CMPO VC VSS PWRUP_B_1V8 PWRUP_N_1V8 IBP_1U<1> LELOTEMP_CMP
xg4 IBP_1U<0> PWRUP_N_1V8 VSS VSS JNWATR_NCH_2C5F0
.ends

* expanding   symbol:  JNW_ATR_SKY130A/JNWATR_PCH_4C5F0.sym # of pins=4
** sym_path: /Users/wulff/data/2023/aicex/ip/lelo_temp_sky130a/design/JNW_ATR_SKY130A/JNWATR_PCH_4C5F0.sym
** sch_path: /Users/wulff/data/2023/aicex/ip/lelo_temp_sky130a/design/JNW_ATR_SKY130A/JNWATR_PCH_4C5F0.sch
.subckt JNWATR_PCH_4C5F0 D G S B
*.iopin D
*.iopin G
*.iopin S
*.iopin B
XM1 D G S B sky130_fd_pr__pfet_01v8 L=0.94 W=3.2 nf=2 ad='int((nf+1)/2) * W/nf * 0.29' as='int((nf+2)/2) * W/nf * 0.29' pd='2*int((nf+1)/2) * (W/nf + 0.29)'
+ ps='2*int((nf+2)/2) * (W/nf + 0.29)' nrd='0.29 / W' nrs='0.29 / W' sa=0 sb=0 sd=0 mult=1 m=1
.ends

* expanding   symbol:  JNW_TR_SKY130A/JNWTR_CAPX1.sym # of pins=2
** sym_path: /Users/wulff/data/2023/aicex/ip/lelo_temp_sky130a/design/JNW_TR_SKY130A/JNWTR_CAPX1.sym
** sch_path: /Users/wulff/data/2023/aicex/ip/lelo_temp_sky130a/design/JNW_TR_SKY130A/JNWTR_CAPX1.sch
.subckt JNWTR_CAPX1 A B
*.iopin A
*.iopin B
XC1 B A sky130_fd_pr__cap_mim_m3_1 W=5 L=5 MF=1 m=1
.ends

* expanding   symbol:  LELO_TEMP_SKY130A/LELOTEMP_OTA.sym # of pins=8
** sym_path: /Users/wulff/data/2023/aicex/ip/lelo_temp_sky130a/design/LELO_TEMP_SKY130A/LELOTEMP_OTA.sym
** sch_path: /Users/wulff/data/2023/aicex/ip/lelo_temp_sky130a/design/LELO_TEMP_SKY130A/LELOTEMP_OTA.sch
.subckt LELOTEMP_OTA VDD_1V8 VIP VO VIN VSS PWRUP_1V8 PWRUP_N_1V8 VCP
*.opin VO
*.ipin VIP
*.ipin VIN
*.ipin VDD_1V8
*.ipin VSS
*.ipin PWRUP_N_1V8
*.ipin PWRUP_1V8
*.opin VCP
xnd1<3> VD1 VD1 VSS VSS JNWATR_NCH_4C5F0
xnd1<2> VD1 VD1 VSS VSS JNWATR_NCH_4C5F0
xnd1<1> VD1 VD1 VSS VSS JNWATR_NCH_4C5F0
xnd1<0> VD1 VD1 VSS VSS JNWATR_NCH_4C5F0
xnd2<3> VD2 VD2 VSS VSS JNWATR_NCH_4C5F0
xnd2<2> VD2 VD2 VSS VSS JNWATR_NCH_4C5F0
xnd2<1> VD2 VD2 VSS VSS JNWATR_NCH_4C5F0
xnd2<0> VD2 VD2 VSS VSS JNWATR_NCH_4C5F0
xba6 VBP VBP VDD_1V8 VDD_1V8 JNWATR_PCH_12C5F0
xnd3 VBP VD1 VSS VSS JNWATR_NCH_4C5F0
xba8 VO VBP VDD_1V8 VDD_1V8 JNWATR_PCH_12C5F0
xnd4 VO VD2 VSS VSS JNWATR_NCH_4C5F0
xd2 net1 VS VSS JNWTR_RPPO8
xba7 VBP PWRUP_1V8 VDD_1V8 VDD_1V8 JNWATR_PCH_12C5F0
xba1 net1 PWRUP_N_1V8 VDD_1V8 VDD_1V8 JNWATR_PCH_12C5F0
xba2 VO PWRUP_1V8 VDD_1V8 VDD_1V8 JNWATR_PCH_12C5F0
xns1 VD1 PWRUP_N_1V8 VSS VSS JNWATR_NCH_4C5F0
xns2 VD2 PWRUP_N_1V8 VSS VSS JNWATR_NCH_4C5F0
xnc0 VD3 VD3 VSS VSS JNWATR_NCH_4C5F0
xnc1<2> VCP VD3 VSS VSS JNWATR_NCH_4C5F0
xnc1<1> VCP VD3 VSS VSS JNWATR_NCH_4C5F0
xnc1<0> VCP VD3 VSS VSS JNWATR_NCH_4C5F0
xbs6 net2 VCP VDD_1V8 VDD_1V8 JNWATR_PCH_4C1F2
xbs1 net3 VCP net2 VDD_1V8 JNWATR_PCH_4C1F2
xbs2 net5 VCP net3 VDD_1V8 JNWATR_PCH_4C1F2
xbs4 net4 VCP net5 VDD_1V8 JNWATR_PCH_4C1F2
xbs7 net6 VCP net4 VDD_1V8 JNWATR_PCH_4C1F2
xns4 VD3 PWRUP_N_1V8 VSS VSS JNWATR_NCH_4C5F0
xba3 VCP PWRUP_1V8 VDD_1V8 VDD_1V8 JNWATR_PCH_12C5F0
xbs8 VCP VCP net6 VDD_1V8 JNWATR_PCH_4C1F2
xbl1<3> VD1 VIN VS VDD_1V8 LELOATR_LVT_PCH_12C5F0
xbl1<2> VD1 VIN VS VDD_1V8 LELOATR_LVT_PCH_12C5F0
xbl1<1> VD1 VIN VS VDD_1V8 LELOATR_LVT_PCH_12C5F0
xbl1<0> VD1 VIN VS VDD_1V8 LELOATR_LVT_PCH_12C5F0
xbl0<3> VD2 VIP VS VDD_1V8 LELOATR_LVT_PCH_12C5F0
xbl0<2> VD2 VIP VS VDD_1V8 LELOATR_LVT_PCH_12C5F0
xbl0<1> VD2 VIP VS VDD_1V8 LELOATR_LVT_PCH_12C5F0
xbl0<0> VD2 VIP VS VDD_1V8 LELOATR_LVT_PCH_12C5F0
xbl4 VD3 VIN VS VDD_1V8 LELOATR_LVT_PCH_12C5F0
xbl5 VD3 VIP VS VDD_1V8 LELOATR_LVT_PCH_12C5F0
.ends

* expanding   symbol:  JNW_TR_SKY130A/JNWTR_RPPO4.sym # of pins=3
** sym_path: /Users/wulff/data/2023/aicex/ip/lelo_temp_sky130a/design/JNW_TR_SKY130A/JNWTR_RPPO4.sym
** sch_path: /Users/wulff/data/2023/aicex/ip/lelo_temp_sky130a/design/JNW_TR_SKY130A/JNWTR_RPPO4.sch
.subckt JNWTR_RPPO4 N P B
*.iopin P
*.iopin N
*.iopin B
XXA1 N P B JNWTR_RES4
.ends

* expanding   symbol:  JNW_BIAS_SKY130A/JNWBIAS_BIPOLAR.sym # of pins=3
** sym_path: /Users/wulff/data/2023/aicex/ip/lelo_temp_sky130a/design/JNW_BIAS_SKY130A/JNWBIAS_BIPOLAR.sym
** sch_path: /Users/wulff/data/2023/aicex/ip/lelo_temp_sky130a/design/JNW_BIAS_SKY130A/JNWBIAS_BIPOLAR.sch
.subckt JNWBIAS_BIPOLAR VD2 VD1 VSS
*.ipin VSS
*.ipin VD1
*.ipin VD2
XQ1 VSS VSS VD1 sky130_fd_pr__pnp_05v5_W3p40L3p40 m=1 mult=1
XQ2<7> VSS VSS VD2 sky130_fd_pr__pnp_05v5_W3p40L3p40 m=1 mult=1
XQ2<6> VSS VSS VD2 sky130_fd_pr__pnp_05v5_W3p40L3p40 m=1 mult=1
XQ2<5> VSS VSS VD2 sky130_fd_pr__pnp_05v5_W3p40L3p40 m=1 mult=1
XQ2<4> VSS VSS VD2 sky130_fd_pr__pnp_05v5_W3p40L3p40 m=1 mult=1
XQ2<3> VSS VSS VD2 sky130_fd_pr__pnp_05v5_W3p40L3p40 m=1 mult=1
XQ2<2> VSS VSS VD2 sky130_fd_pr__pnp_05v5_W3p40L3p40 m=1 mult=1
XQ2<1> VSS VSS VD2 sky130_fd_pr__pnp_05v5_W3p40L3p40 m=1 mult=1
XQ2<0> VSS VSS VD2 sky130_fd_pr__pnp_05v5_W3p40L3p40 m=1 mult=1
.ends

* expanding   symbol:  JNW_ATR_SKY130A/JNWATR_NCH_4C5F0.sym # of pins=4
** sym_path: /Users/wulff/data/2023/aicex/ip/lelo_temp_sky130a/design/JNW_ATR_SKY130A/JNWATR_NCH_4C5F0.sym
** sch_path: /Users/wulff/data/2023/aicex/ip/lelo_temp_sky130a/design/JNW_ATR_SKY130A/JNWATR_NCH_4C5F0.sch
.subckt JNWATR_NCH_4C5F0 D G S B
*.iopin D
*.iopin G
*.iopin S
*.iopin B
XM1 D G S B sky130_fd_pr__nfet_01v8 L=0.94 W=3.2 nf=2 ad='int((nf+1)/2) * W/nf * 0.29' as='int((nf+2)/2) * W/nf * 0.29' pd='2*int((nf+1)/2) * (W/nf + 0.29)'
+ ps='2*int((nf+2)/2) * (W/nf + 0.29)' nrd='0.29 / W' nrs='0.29 / W' sa=0 sb=0 sd=0 mult=1 m=1
.ends

* expanding   symbol:  JNW_TR_SKY130A/JNWTR_RPPO8.sym # of pins=3
** sym_path: /Users/wulff/data/2023/aicex/ip/lelo_temp_sky130a/design/JNW_TR_SKY130A/JNWTR_RPPO8.sym
** sch_path: /Users/wulff/data/2023/aicex/ip/lelo_temp_sky130a/design/JNW_TR_SKY130A/JNWTR_RPPO8.sch
.subckt JNWTR_RPPO8 N P B
*.iopin P
*.iopin N
*.iopin B
XXA1 N P B JNWTR_RES8
.ends

* expanding   symbol:  JNW_ATR_SKY130A/JNWATR_PCH_4C1F2.sym # of pins=4
** sym_path: /Users/wulff/data/2023/aicex/ip/lelo_temp_sky130a/design/JNW_ATR_SKY130A/JNWATR_PCH_4C1F2.sym
** sch_path: /Users/wulff/data/2023/aicex/ip/lelo_temp_sky130a/design/JNW_ATR_SKY130A/JNWATR_PCH_4C1F2.sch
.subckt JNWATR_PCH_4C1F2 D G S B
*.iopin D
*.iopin G
*.iopin S
*.iopin B
XM1 D G S B sky130_fd_pr__pfet_01v8 L=0.22 W=3.2 nf=2 ad='int((nf+1)/2) * W/nf * 0.29' as='int((nf+2)/2) * W/nf * 0.29' pd='2*int((nf+1)/2) * (W/nf + 0.29)'
+ ps='2*int((nf+2)/2) * (W/nf + 0.29)' nrd='0.29 / W' nrs='0.29 / W' sa=0 sb=0 sd=0 mult=1 m=1
.ends

* expanding   symbol:  JNW_ATR_SKY130A/JNWATR_PCH_2C5F0.sym # of pins=4
** sym_path: /Users/wulff/data/2023/aicex/ip/lelo_temp_sky130a/design/JNW_ATR_SKY130A/JNWATR_PCH_2C5F0.sym
** sch_path: /Users/wulff/data/2023/aicex/ip/lelo_temp_sky130a/design/JNW_ATR_SKY130A/JNWATR_PCH_2C5F0.sch
.subckt JNWATR_PCH_2C5F0 D G S B
*.iopin D
*.iopin G
*.iopin S
*.iopin B
XM1 D G S B sky130_fd_pr__pfet_01v8 L=0.94 W=1.92 nf=2 ad='int((nf+1)/2) * W/nf * 0.29' as='int((nf+2)/2) * W/nf * 0.29' pd='2*int((nf+1)/2) * (W/nf + 0.29)'
+ ps='2*int((nf+2)/2) * (W/nf + 0.29)' nrd='0.29 / W' nrs='0.29 / W' sa=0 sb=0 sd=0 mult=1 m=1
.ends

* expanding   symbol:  JNW_TR_SKY130A/JNWTR_NCHDL.sym # of pins=4
** sym_path: /Users/wulff/data/2023/aicex/ip/lelo_temp_sky130a/design/JNW_TR_SKY130A/JNWTR_NCHDL.sym
** sch_path: /Users/wulff/data/2023/aicex/ip/lelo_temp_sky130a/design/JNW_TR_SKY130A/JNWTR_NCHDL.sch
.subckt JNWTR_NCHDL D G S B
*.iopin D
*.iopin G
*.iopin S
*.iopin B
XM1 D G S B sky130_fd_pr__nfet_01v8 L=0.16 W=0.9 nf=1 ad='int((nf+1)/2) * W/nf * 0.29' as='int((nf+2)/2) * W/nf * 0.29' pd='2*int((nf+1)/2) * (W/nf + 0.29)'
+ ps='2*int((nf+2)/2) * (W/nf + 0.29)' nrd='0.29 / W' nrs='0.29 / W' sa=0 sb=0 sd=0 mult=1 m=1
.ends

* expanding   symbol:  JNW_TR_SKY130A/JNWTR_PCHDL.sym # of pins=4
** sym_path: /Users/wulff/data/2023/aicex/ip/lelo_temp_sky130a/design/JNW_TR_SKY130A/JNWTR_PCHDL.sym
** sch_path: /Users/wulff/data/2023/aicex/ip/lelo_temp_sky130a/design/JNW_TR_SKY130A/JNWTR_PCHDL.sch
.subckt JNWTR_PCHDL D G S B
*.iopin D
*.iopin G
*.iopin S
*.iopin B
XM1 D G S B sky130_fd_pr__pfet_01v8 L=0.16 W=0.9 nf=1 ad='int((nf+1)/2) * W/nf * 0.29' as='int((nf+2)/2) * W/nf * 0.29' pd='2*int((nf+1)/2) * (W/nf + 0.29)'
+ ps='2*int((nf+2)/2) * (W/nf + 0.29)' nrd='0.29 / W' nrs='0.29 / W' sa=0 sb=0 sd=0 mult=1 m=1
.ends

* expanding   symbol:  JNW_ATR_SKY130A/JNWATR_NCH_2C5F0.sym # of pins=4
** sym_path: /Users/wulff/data/2023/aicex/ip/lelo_temp_sky130a/design/JNW_ATR_SKY130A/JNWATR_NCH_2C5F0.sym
** sch_path: /Users/wulff/data/2023/aicex/ip/lelo_temp_sky130a/design/JNW_ATR_SKY130A/JNWATR_NCH_2C5F0.sch
.subckt JNWATR_NCH_2C5F0 D G S B
*.iopin D
*.iopin G
*.iopin S
*.iopin B
XM1 D G S B sky130_fd_pr__nfet_01v8 L=0.94 W=1.92 nf=2 ad='int((nf+1)/2) * W/nf * 0.29' as='int((nf+2)/2) * W/nf * 0.29' pd='2*int((nf+1)/2) * (W/nf + 0.29)'
+ ps='2*int((nf+2)/2) * (W/nf + 0.29)' nrd='0.29 / W' nrs='0.29 / W' sa=0 sb=0 sd=0 mult=1 m=1
.ends

* expanding   symbol:  LELO_TEMP_SKY130A/LELOTEMP_CMP.sym # of pins=8
** sym_path: /Users/wulff/data/2023/aicex/ip/lelo_temp_sky130a/design/LELO_TEMP_SKY130A/LELOTEMP_CMP.sym
** sch_path: /Users/wulff/data/2023/aicex/ip/lelo_temp_sky130a/design/LELO_TEMP_SKY130A/LELOTEMP_CMP.sch
.subckt LELOTEMP_CMP VDD_1V8 VIP VO VIN VSS PWRUP_1V8 PWRUP_N_1V8 IBP_1U
*.opin VO
*.ipin VIP
*.ipin VIN
*.ipin VDD_1V8
*.ipin VSS
*.ipin PWRUP_N_1V8
*.ipin PWRUP_1V8
*.ipin IBP_1U
xn_mirr_load2 VBN1 VBN1 VSS VSS JNWATR_NCH_2C5F0
xn_mirr_load3 VO1 VBN1 VSS VSS JNWATR_NCH_2C5F0
xp_mirr_tail2 VO VBP2 VDD_1V8 VDD_1V8 JNWATR_PCH_2C5F0
xn_mirr_load5 VO VO1 VSS VSS JNWATR_NCH_2C1F2
xp_mirr_tail1<0> VBP2 PWRUP_1V8 VDD_1V8 VDD_1V8 JNWATR_PCH_2C5F0
xn_mirr_load1 VBN1 PWRUP_N_1V8 VSS VSS JNWATR_NCH_2C5F0
xn_mirr_load4 VO PWRUP_N_1V8 VSS VSS JNWATR_NCH_2C5F0
xn_mirr_bias1 IBP_1U IBP_1U VSS VSS JNWATR_NCH_2C5F0
xn_mirr_bias2<3> VBP2 IBP_1U VSS VSS JNWATR_NCH_2C5F0
xn_mirr_bias2<2> VBP2 IBP_1U VSS VSS JNWATR_NCH_2C5F0
xn_mirr_bias2<1> VBP2 IBP_1U VSS VSS JNWATR_NCH_2C5F0
xn_mirr_bias2<0> VBP2 IBP_1U VSS VSS JNWATR_NCH_2C5F0
xn_mirr_bias3 IBP_1U PWRUP_N_1V8 VSS VSS JNWATR_NCH_2C5F0
xp_mirr_tail1 VBP2 VBP2 VDD_1V8 VDD_1V8 JNWATR_PCH_2C5F0
xp_mirr_tail3<2> VS VBP2 VDD_1V8 VDD_1V8 JNWATR_PCH_2C5F0
xp_mirr_tail3<1> VS VBP2 VDD_1V8 VDD_1V8 JNWATR_PCH_2C5F0
xp_mirr_tail3<0> VS VBP2 VDD_1V8 VDD_1V8 JNWATR_PCH_2C5F0
xp_diff2 VO1 VIP VS VDD_1V8 JNWATR_PCH_2C1F2
xp_diff1 VBN1 VIN VS VDD_1V8 JNWATR_PCH_2C1F2
xp_diff3<3> VDD_1V8 VDD_1V8 VDD_1V8 VDD_1V8 JNWATR_PCH_2C1F2
xp_diff3<2> VDD_1V8 VDD_1V8 VDD_1V8 VDD_1V8 JNWATR_PCH_2C1F2
xp_diff3<1> VDD_1V8 VDD_1V8 VDD_1V8 VDD_1V8 JNWATR_PCH_2C1F2
xp_diff3<0> VDD_1V8 VDD_1V8 VDD_1V8 VDD_1V8 JNWATR_PCH_2C1F2
xn_mirr_load0 VSS VSS VSS VSS JNWATR_NCH_2C5F0
.ends

* expanding   symbol:  JNW_ATR_SKY130A/JNWATR_PCH_12C5F0.sym # of pins=4
** sym_path: /Users/wulff/data/2023/aicex/ip/lelo_temp_sky130a/design/JNW_ATR_SKY130A/JNWATR_PCH_12C5F0.sym
** sch_path: /Users/wulff/data/2023/aicex/ip/lelo_temp_sky130a/design/JNW_ATR_SKY130A/JNWATR_PCH_12C5F0.sch
.subckt JNWATR_PCH_12C5F0 D G S B
*.iopin D
*.iopin G
*.iopin S
*.iopin B
XM1 D G S B sky130_fd_pr__pfet_01v8 L=0.94 W=8.32 nf=2 ad='int((nf+1)/2) * W/nf * 0.29' as='int((nf+2)/2) * W/nf * 0.29' pd='2*int((nf+1)/2) * (W/nf + 0.29)'
+ ps='2*int((nf+2)/2) * (W/nf + 0.29)' nrd='0.29 / W' nrs='0.29 / W' sa=0 sb=0 sd=0 mult=1 m=1
.ends

* expanding   symbol:  LELO_ATR_SKY130A/LELOATR_LVT_PCH_12C5F0.sym # of pins=4
** sym_path: /Users/wulff/data/2023/aicex/ip/lelo_temp_sky130a/design/LELO_ATR_SKY130A/LELOATR_LVT_PCH_12C5F0.sym
** sch_path: /Users/wulff/data/2023/aicex/ip/lelo_temp_sky130a/design/LELO_ATR_SKY130A/LELOATR_LVT_PCH_12C5F0.sch
.subckt LELOATR_LVT_PCH_12C5F0 D G S B
*.iopin D
*.iopin G
*.iopin S
*.iopin B
XM1 D G S B sky130_fd_pr__pfet_01v8_lvt L=0.94 W=8.32 nf=2 ad='int((nf+1)/2) * W/nf * 0.29' as='int((nf+2)/2) * W/nf * 0.29' pd='2*int((nf+1)/2) * (W/nf + 0.29)'
+ ps='2*int((nf+2)/2) * (W/nf + 0.29)' nrd='0.29 / W' nrs='0.29 / W' sa=0 sb=0 sd=0 mult=1 m=1
.ends

* expanding   symbol:  JNW_TR_SKY130A/JNWTR_RES4.sym # of pins=3
** sym_path: /Users/wulff/data/2023/aicex/ip/lelo_temp_sky130a/design/JNW_TR_SKY130A/JNWTR_RES4.sym
** sch_path: /Users/wulff/data/2023/aicex/ip/lelo_temp_sky130a/design/JNW_TR_SKY130A/JNWTR_RES4.sch
.subckt JNWTR_RES4 N P B
*.iopin N
*.iopin P
*.iopin B
XR1_0 INT_0 N B sky130_fd_pr__res_high_po W=0.36 L=7.36 mult=1 m=1
XR1_1 INT_1 INT_0 B sky130_fd_pr__res_high_po W=0.36 L=7.36 mult=1 m=1
XR1_2 INT_2 INT_1 B sky130_fd_pr__res_high_po W=0.36 L=7.36 mult=1 m=1
XR1_3 P INT_2 B sky130_fd_pr__res_high_po W=0.36 L=7.36 mult=1 m=1
.ends

* expanding   symbol:  JNW_TR_SKY130A/JNWTR_RES8.sym # of pins=3
** sym_path: /Users/wulff/data/2023/aicex/ip/lelo_temp_sky130a/design/JNW_TR_SKY130A/JNWTR_RES8.sym
** sch_path: /Users/wulff/data/2023/aicex/ip/lelo_temp_sky130a/design/JNW_TR_SKY130A/JNWTR_RES8.sch
.subckt JNWTR_RES8 N P B
*.iopin N
*.iopin P
*.iopin B
XR1_0 INT_0 N B sky130_fd_pr__res_high_po W=0.36 L=7.36 mult=1 m=1
XR1_1 INT_1 INT_0 B sky130_fd_pr__res_high_po W=0.36 L=7.36 mult=1 m=1
XR1_2 INT_2 INT_1 B sky130_fd_pr__res_high_po W=0.36 L=7.36 mult=1 m=1
XR1_3 INT_3 INT_2 B sky130_fd_pr__res_high_po W=0.36 L=7.36 mult=1 m=1
XR1_4 INT_4 INT_3 B sky130_fd_pr__res_high_po W=0.36 L=7.36 mult=1 m=1
XR1_5 INT_5 INT_4 B sky130_fd_pr__res_high_po W=0.36 L=7.36 mult=1 m=1
XR1_6 INT_6 INT_5 B sky130_fd_pr__res_high_po W=0.36 L=7.36 mult=1 m=1
XR1_7 P INT_6 B sky130_fd_pr__res_high_po W=0.36 L=7.36 mult=1 m=1
.ends

* expanding   symbol:  JNW_ATR_SKY130A/JNWATR_NCH_2C1F2.sym # of pins=4
** sym_path: /Users/wulff/data/2023/aicex/ip/lelo_temp_sky130a/design/JNW_ATR_SKY130A/JNWATR_NCH_2C1F2.sym
** sch_path: /Users/wulff/data/2023/aicex/ip/lelo_temp_sky130a/design/JNW_ATR_SKY130A/JNWATR_NCH_2C1F2.sch
.subckt JNWATR_NCH_2C1F2 D G S B
*.iopin D
*.iopin G
*.iopin S
*.iopin B
XM1 D G S B sky130_fd_pr__nfet_01v8 L=0.22 W=1.92 nf=2 ad='int((nf+1)/2) * W/nf * 0.29' as='int((nf+2)/2) * W/nf * 0.29' pd='2*int((nf+1)/2) * (W/nf + 0.29)'
+ ps='2*int((nf+2)/2) * (W/nf + 0.29)' nrd='0.29 / W' nrs='0.29 / W' sa=0 sb=0 sd=0 mult=1 m=1
.ends

* expanding   symbol:  JNW_ATR_SKY130A/JNWATR_PCH_2C1F2.sym # of pins=4
** sym_path: /Users/wulff/data/2023/aicex/ip/lelo_temp_sky130a/design/JNW_ATR_SKY130A/JNWATR_PCH_2C1F2.sym
** sch_path: /Users/wulff/data/2023/aicex/ip/lelo_temp_sky130a/design/JNW_ATR_SKY130A/JNWATR_PCH_2C1F2.sch
.subckt JNWATR_PCH_2C1F2 D G S B
*.iopin D
*.iopin G
*.iopin S
*.iopin B
XM1 D G S B sky130_fd_pr__pfet_01v8 L=0.22 W=1.92 nf=2 ad='int((nf+1)/2) * W/nf * 0.29' as='int((nf+2)/2) * W/nf * 0.29' pd='2*int((nf+1)/2) * (W/nf + 0.29)'
+ ps='2*int((nf+2)/2) * (W/nf + 0.29)' nrd='0.29 / W' nrs='0.29 / W' sa=0 sb=0 sd=0 mult=1 m=1
.ends

.end
