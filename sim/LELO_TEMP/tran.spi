*TB_SUN_TR_SKY130NM/TB_NCM
*----------------------------------------------------------------
* Include
*----------------------------------------------------------------
#ifdef Lay
.include ../../../work/lpe/LELO_TEMP_lpe.spi
#else
.include ../../../work/xsch/LELO_TEMP.spice
#endif

*-----------------------------------------------------------------
* OPTIONS
*-----------------------------------------------------------------
.option TNOM=27 GMIN=1e-15 reltol=1e-4 method=gear
.options sparse
*-----------------------------------------------------------------
* PARAMETERS
*-----------------------------------------------------------------
.param TRF = 10p

.param AVDD = {vdda}

*-----------------------------------------------------------------
* FORCE
*-----------------------------------------------------------------
VSS  VSS  0     dc 0
VDD  VDD_1V8  VSS  pwl 0 0 10n {AVDD}
VPWR  PWRUP_1V8  VSS  pwl 0 0 {t_start} 0 {{t_start} + 10p} {AVDD}

*-----------------------------------------------------------------
* DUT
*-----------------------------------------------------------------
.include ../xdut.spi

*----------------------------------------------------------------
* PROBE
*----------------------------------------------------------------
*.save all
.save v(vdd_1v8) v(vss) v(pwrup_1v8) v(osc_temp_1v8)
.save i(vdd)

*- Internal probes. The layout wraps the blocks in LELO_TEMP_BIAS /
*- LELO_TEMP_CCMP cells that the schematic does not have, and the LPE is
*- flat, so every internal node carries the wrapper instance in its name
*- (VC -> xbias.VC). The bias subcells are split further still
*- (x1_ibp.VR1 -> xbias.x1_ibp.xr_lad.VR1). Only the four ports are
*- common to both views, so the rest has to be spelled out per view.
#ifdef Lay
.save v(xdut.xbias.x1_ibp.LPI) v(xdut.xbias.vc)
.save v(xdut.xbias.ibp_1u<0>) v(xdut.xbias.ibp_1u<1>) v(xdut.xbias.ibp_1u<2>) v(xdut.xbias.ibp_1u<3>)
.save v(xdut.xccmp.rst_a) v(xdut.xccmp.rst_b)
.save v(xdut.xccmp.cmpo_a) v(xdut.xccmp.cmpo_b)
.save v(xdut.xbias.x1_ibp.xr_lad.vr1) v(xdut.xbias.x1_ibp.xr_lad.vd2)
#else
.save v(xdut.LPI) v(xdut.vc)
.save v(xdut.ibp_1u<0>) v(xdut.ibp_1u<1>) v(xdut.ibp_1u<2>) v(xdut.ibp_1u<3>)
.save v(xdut.rst_a) v(xdut.rst_b)
.save v(xdut.cmpo_a) v(xdut.cmpo_b)
.save v(xdut.x1_ibp.vr1) v(xdut.x1_ibp.vd2)
#endif

#ifdef Debug
.option savecurrents
.save all
#endif
*----------------------------------------------------------------
* NGSPICE control
*----------------------------------------------------------------
.control
*set num_threads=64
*set color0=white
*set color1=black
unset askquit

optran 0 0 0 1n 1u 0

#ifdef Nosweep
tran 0.1n {t_stop}
write {cicname}.raw
#else
set fend = .raw
foreach vtemp {temperatures}
  option temp=$vtemp
  tran 1n {t_stop}
  write {cicname}_$vtemp$fend
end

#endif

quit

.endc

.end
